* Auto-generated SPICE netlist (NO TEXT OCR USED)

R1 0 n2 1k
D1 0 n1 Ddefault
V1 n1 n2 DC 5
.model Ddefault D

.op
.end
