* Auto-generated SPICE netlist (NO TEXT OCR USED)

V1 0 n2 DC 5
R1 n1 n2 1k
D1 0 n1 Ddefault
.model Ddefault D

.op
.end
