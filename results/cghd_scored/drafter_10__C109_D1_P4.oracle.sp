* Auto-generated SPICE netlist (NO TEXT OCR USED)

R1 0 n2 1k
V1 n1 n2 DC 5
D1 n1 0 Ddefault
.model Ddefault D

.op
.end
