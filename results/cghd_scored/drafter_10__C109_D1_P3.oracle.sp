* Auto-generated SPICE netlist (NO TEXT OCR USED)

R1 0 n2 1k
D1 n1 0 Ddefault
V1 n2 n1 DC 5
.model Ddefault D

.op
.end
