* Auto-generated SPICE netlist (NO TEXT OCR USED)

C1 n2 n1 1u
R1 0 n2 1k

.op
.end
