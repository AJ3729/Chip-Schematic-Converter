* Auto-generated SPICE netlist (NO TEXT OCR USED)

V1 0 n1 DC 5
C1 0 n1 1u

.op
.end
