* Auto-generated SPICE netlist (NO TEXT OCR USED)

C1 n3 0 1u
I1 0 n3 DC 1m
I2 n2 0 DC 1m
E1 n1 0 n1 n1 100k

* --- design-intent repair (does not change topology) ---
Rshunt_n1 n1 0 1e+09
Rshunt_n2 n2 0 1e+09
Rshunt_n3 n3 0 1e+09

.op
.end
