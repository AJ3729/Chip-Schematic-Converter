* Auto-generated SPICE netlist (NO TEXT OCR USED)

D1 n1 0 Ddefault
R1 n1 0 1k
R2 0 n2 1k
C1 n1 0 1u
.model Ddefault D

.op
.end
