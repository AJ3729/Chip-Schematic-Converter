* Auto-generated SPICE netlist (NO TEXT OCR USED)

V1 n2 n1 DC 5
V2 0 n3 DC 5
I1 n3 0 AC 1m

* --- design-intent repair (does not change topology) ---
Rshunt_n1 n1 0 1e+09

.op
.end
