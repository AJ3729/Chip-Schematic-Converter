* Auto-generated SPICE netlist (NO TEXT OCR USED)

R1 0 n2 1k
D1 n2 n1 Ddefault
D2 n2 n1 Ddefault
D3 n1 0 Ddefault
D4 n1 0 Ddefault
L1 0 n1 1m
D5 n2 0 Ddefault
.model Ddefault D

.op
.end
