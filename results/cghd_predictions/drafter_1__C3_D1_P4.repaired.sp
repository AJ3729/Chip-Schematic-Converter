* Auto-generated SPICE netlist (NO TEXT OCR USED)

V1 0 n3 DC 5
R1 n1 n2 1k
C1 n1 0 1u

* --- design-intent repair (does not change topology) ---
Rshunt_n1 n1 0 1e+09
Rshunt_n3 n3 0 1e+09

.op
.end
