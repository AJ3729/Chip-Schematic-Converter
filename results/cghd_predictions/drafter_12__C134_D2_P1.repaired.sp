* Auto-generated SPICE netlist (NO TEXT OCR USED)

C1 n1 n3 1u
R1 0 n1 1k
V1 0 n2 AC 1
L1 n2 n3 1m
I1 0 n2 DC 1m

.op
.end
