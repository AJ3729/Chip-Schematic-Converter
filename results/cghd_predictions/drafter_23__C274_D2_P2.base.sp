* Auto-generated SPICE netlist (NO TEXT OCR USED)

C1 n3 0 1u
* SAME_NODE_SKIPPED Capacitor both_on=0
D1 0 n3 Zdefault
L1 n4 0 1m
L2 n1 n2 1m
L3 n4 0 1m
L4 0 n4 1m
* SAME_NODE_SKIPPED Diode both_on=0
.model Zdefault D(bv=5.1)

.op
.end
