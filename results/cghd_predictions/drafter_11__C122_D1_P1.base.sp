* Auto-generated SPICE netlist (NO TEXT OCR USED)

C1 0 n1 1u
* UNSNAPPED Inductor raw_nodes=[5, None]
* SAME_NODE_SKIPPED Capacitor both_on=0
* SAME_NODE_SKIPPED Diode both_on=0

.op
.end
