* Auto-generated SPICE netlist (NO TEXT OCR USED)

L1 0 n1 1m
R1 n2 0 1k
D1 0 n1 Ddefault
D2 0 n2 Ddefault
D3 0 n2 Ddefault
L2 n1 n2 1m
D4 n1 n2 Ddefault
.model Ddefault D

.op
.end
