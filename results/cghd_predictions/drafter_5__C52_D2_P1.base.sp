* Auto-generated SPICE netlist (NO TEXT OCR USED)

* UNSNAPPED Capacitor raw_nodes=[5, None]
* UNSNAPPED Capacitor raw_nodes=[5, None]
Q1 0 0 0 QNPNdefault
* SAME_NODE_SKIPPED V-DC (one port) both_on=0
.model QNPNdefault NPN

.op
.end
