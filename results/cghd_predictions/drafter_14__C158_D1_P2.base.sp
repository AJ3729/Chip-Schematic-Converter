* Auto-generated SPICE netlist (NO TEXT OCR USED)

C1 n3 0 1u
C2 n3 0 1u
C3 n1 n2 1u
C4 n1 0 1u
C5 n4 0 1u
R1 n4 0 1k

.op
.end
