* Auto-generated SPICE netlist (NO TEXT OCR USED)

R1 n2 0 1k
Q1 n3 0 0 QPNPdefault
R2 n2 n4 1k
R3 0 n4 1k
R4 n1 n2 1k
C1 n2 0 1u
R5 n1 n3 1k
.model QPNPdefault PNP

.op
.end
