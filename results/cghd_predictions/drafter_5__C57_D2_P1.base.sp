* Auto-generated SPICE netlist (NO TEXT OCR USED)

C1 n1 0 1u
* SAME_NODE_SKIPPED Capacitor both_on=0
Q1 0 n1 0 QNPNdefault
.model QNPNdefault NPN

.op
.end
