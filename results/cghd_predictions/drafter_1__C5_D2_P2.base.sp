* Auto-generated SPICE netlist (NO TEXT OCR USED)

* SAME_NODE_SKIPPED I-DC both_on=0
R1 n1 0 1k

.op
.end
