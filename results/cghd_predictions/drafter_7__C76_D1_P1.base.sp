* Auto-generated SPICE netlist (NO TEXT OCR USED)

Q1 n1 n2 0 QNPNdefault
Q2 0 n1 0 QPNPdefault
R1 0 n3 1k
.model QNPNdefault NPN
.model QPNPdefault PNP

.op
.end
