* Auto-generated SPICE netlist (NO TEXT OCR USED)

V1 0 n1 DC 5
R1 0 n1 1k
R2 0 n1 1k
R3 0 n1 1k
V2 0 n1 DC 5

.op
.end
