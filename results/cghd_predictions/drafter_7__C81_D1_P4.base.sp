* Auto-generated SPICE netlist (NO TEXT OCR USED)

Q1 n2 0 0 QNPNdefault
R1 0 n4 1k
R2 n2 0 1k
R3 0 n3 1k
R4 0 n4 1k
R5 n1 n2 1k
* SAME_NODE_SKIPPED Resistor both_on=0
R6 n1 0 1k
.model QNPNdefault NPN

.op
.end
