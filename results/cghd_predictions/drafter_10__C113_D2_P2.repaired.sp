* Auto-generated SPICE netlist (NO TEXT OCR USED)

C1 0 n1 1u
* UNSNAPPED Resistor raw_nodes=[4, None]

* --- design-intent repair (does not change topology) ---
Rshunt_n1 n1 0 1e+09

.op
.end
