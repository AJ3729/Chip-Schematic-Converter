* Auto-generated SPICE netlist (NO TEXT OCR USED)

D1 0 n3 Zdefault
C1 0 n5 1u
Q1 n4 0 n3 QPNPdefault
L1 n2 n1 1m
I1 n3 n5 DC 1m
.model QPNPdefault PNP
.model Zdefault D(bv=5.1)

.op
.end
