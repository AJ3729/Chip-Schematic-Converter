* Auto-generated SPICE netlist (NO TEXT OCR USED)

V1 n1 0 AC 1
C1 n2 n3 1u
R1 n1 n2 1k
R2 n3 0 1k
L1 n3 0 1m

.op
.end
