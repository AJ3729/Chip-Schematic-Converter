* Auto-generated SPICE netlist (NO TEXT OCR USED)

* UNSNAPPED Capacitor raw_nodes=[3, None]
C1 0 n1 1u
Q1 0 0 0 QNPNdefault
.model QNPNdefault NPN

.op
.end
