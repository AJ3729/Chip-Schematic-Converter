* Auto-generated SPICE netlist (NO TEXT OCR USED)

Q1 0 n1 n3 QNPNdefault
* UNSNAPPED Resistor raw_nodes=[0, None]
R1 n2 n1 1k
.model QNPNdefault NPN

.op
.end
