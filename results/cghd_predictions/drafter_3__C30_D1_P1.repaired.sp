* Auto-generated SPICE netlist (NO TEXT OCR USED)

R1 n3 n2 1k
D1 n2 0 Ddefault
L1 n1 0 1m
D2 0 n3 Ddefault
D3 n1 n3 Ddefault
D4 0 n3 Ddefault
D5 n1 n2 Zdefault
D6 n2 0 Ddefault
.model Ddefault D
.model Zdefault D(bv=5.1)

.op
.end
