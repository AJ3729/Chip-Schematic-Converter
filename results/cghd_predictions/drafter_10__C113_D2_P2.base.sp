* Auto-generated SPICE netlist (NO TEXT OCR USED)

C1 0 n1 1u
* UNSNAPPED Resistor raw_nodes=[4, None]

.op
.end
