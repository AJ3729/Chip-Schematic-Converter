* Auto-generated SPICE netlist (NO TEXT OCR USED)

D1 n1 0 Zdefault
C1 n2 0 1u
D2 0 n2 Zdefault
C2 n2 0 1u
.model Zdefault D(bv=5.1)

.op
.end
