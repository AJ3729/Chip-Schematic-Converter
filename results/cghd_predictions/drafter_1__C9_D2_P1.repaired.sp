* Auto-generated SPICE netlist (NO TEXT OCR USED)

I1 n4 n2 DC 1m
R1 n1 n2 1k
R2 n2 n3 1k

* --- design-intent repair (does not change topology) ---
Rshunt_n1 n1 0 1e+09
Rshunt_n5 n5 0 1e+09

.op
.end
