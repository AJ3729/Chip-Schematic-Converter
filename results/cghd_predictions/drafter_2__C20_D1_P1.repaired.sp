* Auto-generated SPICE netlist (NO TEXT OCR USED)

* WARNING: no valid components written

.op
.end
