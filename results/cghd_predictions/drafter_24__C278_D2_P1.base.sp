* Auto-generated SPICE netlist (NO TEXT OCR USED)

Q1 n2 n3 0 QNPNdefault
Q2 n2 n3 0 QNPNdefault
D1 n1 0 Ddefault
R1 n1 0 1k
.model Ddefault D
.model QNPNdefault NPN

.op
.end
