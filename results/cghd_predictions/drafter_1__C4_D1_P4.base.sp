* Auto-generated SPICE netlist (NO TEXT OCR USED)

V1 n2 n1 DC 5
V2 n2 n1 DC 5
R1 0 n3 1k
R2 0 n3 1k
R3 0 n3 1k

.op
.end
