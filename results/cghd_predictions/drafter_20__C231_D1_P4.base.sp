* Auto-generated SPICE netlist (NO TEXT OCR USED)

Q1 n3 n7 n11 QNPNdefault
Q2 n8 n9 n11 QNPNdefault
Q3 n9 n9 n11 QNPNdefault
Q4 n12 n11 n12 QPNPdefault
C1 n7 n5 1u
Q5 n7 n5 n3 QPNPdefault
Q6 n3 n4 n8 QNPNdefault
Q7 n5 n6 n13 QNPNdefault
Q8 n4 n10 n8 QNPNdefault
R1 n3 n5 1k
R2 n7 n11 1k
Q9 n6 n9 n14 QNPNdefault
R3 n13 n11 1k
R4 n14 n11 1k
R5 n4 n10 1k
R6 n10 n12 1k
C2 n6 n3 1u
R7 n3 n9 1k
Q10 n3 n4 n3 QPNPdefault
Q11 n3 n4 n4 QPNPdefault
Q12 n6 n3 n3 QPNPdefault
R8 n3 n4 1k
R9 n2 n1 1k
.model QNPNdefault NPN
.model QPNPdefault PNP

.op
.end
