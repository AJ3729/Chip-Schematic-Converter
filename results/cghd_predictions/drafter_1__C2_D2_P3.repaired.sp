* Auto-generated SPICE netlist (NO TEXT OCR USED)

V1 n4 n1 DC 5
C1 n1 n4 1u
R1 n1 n3 1k
R2 n1 n2 1k

* --- design-intent repair (does not change topology) ---
Rshunt_n1 n1 0 1e+09

.op
.end
