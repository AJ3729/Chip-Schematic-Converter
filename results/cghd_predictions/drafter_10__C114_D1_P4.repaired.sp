* Auto-generated SPICE netlist (NO TEXT OCR USED)

V1 0 n2 AC 1
R1 0 n1 1k
I1 0 n2 AC 1m

* --- design-intent repair (does not change topology) ---
Rshunt_n1 n1 0 1e+09

.op
.end
