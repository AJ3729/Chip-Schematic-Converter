* Auto-generated SPICE netlist (NO TEXT OCR USED)

* SAME_NODE_SKIPPED Resistor both_on=0
L1 n1 0 1m
L2 0 n2 1m

.op
.end
