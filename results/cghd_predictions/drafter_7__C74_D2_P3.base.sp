* Auto-generated SPICE netlist (NO TEXT OCR USED)

R1 n2 0 1k
R2 0 n1 1k

.op
.end
