* Auto-generated SPICE netlist (NO TEXT OCR USED)

V1 0 n2 AC 1
R1 0 n1 1k
* SAME_NODE_SKIPPED Capacitor both_on=n3

* --- design-intent repair (does not change topology) ---
Rshunt_n1 n1 0 1e+09
Rshunt_n2 n2 0 1e+09
Rshunt_n3 n3 0 1e+09

.op
.end
