* Auto-generated SPICE netlist (NO TEXT OCR USED)

D1 n4 n2 Zdefault
C1 n1 n3 1u
.model Zdefault D(bv=5.1)

* --- design-intent repair (does not change topology) ---
Rshunt_n1 n1 0 1e+09
Rshunt_n2 n2 0 1e+09

.op
.end
