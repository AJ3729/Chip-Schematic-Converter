* Auto-generated SPICE netlist (NO TEXT OCR USED)

I1 n10 n6 AC 1m
R1 n5 n6 1k
I2 n5 n6 AC 1m
C1 n11 n10 1u
R2 n10 n6 1k
C2 n6 n9 1u
R3 n1 n6 1k
R4 n2 n6 1k
R5 n1 n5 1k
R6 n1 n4 1k
R7 n6 n7 1k
E1 n8 0 n8 n1 100k
C3 n4 n2 1u
R8 n9 n3 1k
C4 n1 n5 1u

.op
.end
