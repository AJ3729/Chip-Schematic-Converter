* Auto-generated SPICE netlist (NO TEXT OCR USED)

C1 0 n4 1u
R1 n1 0 1k
V1 n3 0 DC 5
R2 n2 0 1k

* --- design-intent repair (does not change topology) ---
Rshunt_n1 n1 0 1e+09
Rshunt_n2 n2 0 1e+09
Rshunt_n3 n3 0 1e+09
Rshunt_n4 n4 0 1e+09

.op
.end
