* Auto-generated SPICE netlist (NO TEXT OCR USED)

R1 n5 n4 1k
C1 0 n2 1u
* UNSNAPPED Resistor raw_nodes=[4, None]
Q1 n3 n3 n3 QPNPdefault
M1 n2 n1 0 0 PMOSdefault
* UNSNAPPED Inductor raw_nodes=[2, None]
.model PMOSdefault PMOS
.model QPNPdefault PNP

.op
.end
