* Auto-generated SPICE netlist (NO TEXT OCR USED)

* SAME_NODE_SKIPPED Capacitor both_on=n4
C1 n7 n6 1u
C2 n16 n18 1u
L1 n4 n6 1m
R1 n14 n12 1k
C3 n8 n5 1u
R2 n13 n17 1k
C4 n15 n4 1u
C5 n6 n11 1u
V1 n4 n2 DC 5
C6 n1 n3 1u
C7 n8 n13 1u
R3 n11 n10 1k
R4 n9 n6 1k
R5 n18 n8 1k
C8 n13 n15 1u

.op
.end
