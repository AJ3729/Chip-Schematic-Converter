* Auto-generated SPICE netlist (NO TEXT OCR USED)

* SAME_NODE_SKIPPED I-AC both_on=n2
I1 n4 n2 AC 1m
I2 n3 n2 AC 1m
* SAME_NODE_SKIPPED I-AC both_on=n2
* SAME_NODE_SKIPPED Capacitor both_on=n2
* UNSNAPPED Capacitor raw_nodes=[6, None]
C1 n1 n2 1u
I3 n2 n3 AC 1m

.op
.end
