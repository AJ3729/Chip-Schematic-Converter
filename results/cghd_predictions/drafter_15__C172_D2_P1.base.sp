* Auto-generated SPICE netlist (NO TEXT OCR USED)

M1 0 0 0 0 PMOSdefault
* SAME_NODE_SKIPPED I-DC both_on=0
* SAME_NODE_SKIPPED Resistor both_on=0
* SAME_NODE_SKIPPED I-DC both_on=0
* SAME_NODE_SKIPPED Resistor both_on=0
Q1 0 0 0 QNPNdefault
* SAME_NODE_SKIPPED Resistor both_on=0
R1 n1 0 1k
M2 0 0 0 0 PMOSdefault
.model PMOSdefault PMOS
.model QNPNdefault NPN

.op
.end
