* Auto-generated SPICE netlist (NO TEXT OCR USED)

* SAME_NODE_SKIPPED Resistor both_on=0
R1 0 n3 1k
R2 0 n2 1k
* SAME_NODE_SKIPPED Resistor both_on=0
R3 0 n2 1k
R4 n1 0 1k
R5 n1 0 1k

* --- design-intent repair (does not change topology) ---
Rshunt_n3 n3 0 1e+09

.op
.end
