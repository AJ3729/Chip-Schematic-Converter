* Auto-generated SPICE netlist (NO TEXT OCR USED)

V1 n2 0 DC 5
R1 n2 n1 1k
R2 0 n1 1k
R3 0 n3 1k

* --- design-intent repair (does not change topology) ---
Rshunt_n3 n3 0 1e+09

.op
.end
