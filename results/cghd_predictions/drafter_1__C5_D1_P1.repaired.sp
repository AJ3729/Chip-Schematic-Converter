* Auto-generated SPICE netlist (NO TEXT OCR USED)

R1 0 n2 1k
R2 0 n2 1k
R3 n2 n1 1k
V1 n1 0 DC 5

.op
.end
