* Auto-generated SPICE netlist (NO TEXT OCR USED)

C1 0 n2 1u
R1 n1 0 1k
V1 n1 n2 AC 1

.op
.end
