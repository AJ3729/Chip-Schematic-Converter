* Auto-generated SPICE netlist (NO TEXT OCR USED)

E1 n1 0 n1 n1 100k

* --- design-intent repair (does not change topology) ---
Rshunt_n1 n1 0 1e+09

.op
.end
