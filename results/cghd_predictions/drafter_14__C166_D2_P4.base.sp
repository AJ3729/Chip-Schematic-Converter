* Auto-generated SPICE netlist (NO TEXT OCR USED)

R1 n1 0 1k
C1 0 n2 1u
D1 0 n2 Zdefault
.model Zdefault D(bv=5.1)

.op
.end
