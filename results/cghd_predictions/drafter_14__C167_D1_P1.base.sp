* Auto-generated SPICE netlist (NO TEXT OCR USED)

I1 n1 0 AC 1m
L1 n2 0 1m

.op
.end
