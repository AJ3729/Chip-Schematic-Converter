* Auto-generated SPICE netlist (NO TEXT OCR USED)

Q1 0 n1 0 QNPNdefault
Q2 n3 n2 n1 QNPNdefault
R1 0 n4 1k
.model QNPNdefault NPN

.op
.end
