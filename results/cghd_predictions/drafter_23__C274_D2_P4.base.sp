* Auto-generated SPICE netlist (NO TEXT OCR USED)

C1 n1 0 1u
* SAME_NODE_SKIPPED Resistor both_on=0
L1 n2 0 1m
L2 0 n2 1m
D1 0 n1 Zdefault
.model Zdefault D(bv=5.1)

.op
.end
