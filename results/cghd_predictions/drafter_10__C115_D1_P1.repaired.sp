* Auto-generated SPICE netlist (NO TEXT OCR USED)

R1 0 n2 1k
C1 n1 n3 1u
C2 0 n3 1u
L1 n2 n1 1m

* --- design-intent repair (does not change topology) ---
Rshunt_n3 n3 0 1e+09

.op
.end
