* Auto-generated SPICE netlist (NO TEXT OCR USED)

* SAME_NODE_SKIPPED Capacitor both_on=0
D1 n1 0 Zdefault
D2 0 n2 Zdefault
C1 n2 0 1u
.model Zdefault D(bv=5.1)

.op
.end
