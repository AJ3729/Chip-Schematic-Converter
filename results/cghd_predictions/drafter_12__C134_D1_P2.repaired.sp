* Auto-generated SPICE netlist (NO TEXT OCR USED)

V1 0 n5 AC 1
C1 n3 n4 1u
R1 0 n3 1k
L1 n5 n4 1m
R2 n1 n2 1k

* --- design-intent repair (does not change topology) ---
Rshunt_n1 n1 0 1e+09

.op
.end
