* Auto-generated SPICE netlist (NO TEXT OCR USED)

* SAME_NODE_SKIPPED I-DC both_on=0
* UNSNAPPED BJT-PNP raw_nodes=[0, None, None]
* SAME_NODE_SKIPPED V-DC both_on=0
* WARNING: no valid components written

.op
.end
