* Auto-generated SPICE netlist (NO TEXT OCR USED)

C1 0 n1 1u
* SAME_NODE_SKIPPED Zener Diode both_on=0
C2 n1 0 1u
* SAME_NODE_SKIPPED Diode both_on=0

* --- design-intent repair (does not change topology) ---
Rshunt_n1 n1 0 1e+09

.op
.end
