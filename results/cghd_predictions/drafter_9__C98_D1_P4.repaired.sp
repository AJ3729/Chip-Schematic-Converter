* Auto-generated SPICE netlist (NO TEXT OCR USED)

* SAME_NODE_SKIPPED V-DC both_on=0
I1 n1 0 DC 1m
V1 n1 0 AC 1
* SAME_NODE_SKIPPED V-DC both_on=0

.op
.end
