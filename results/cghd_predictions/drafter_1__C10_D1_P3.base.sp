* Auto-generated SPICE netlist (NO TEXT OCR USED)

* SAME_NODE_SKIPPED Resistor both_on=0
C1 0 n2 1u
I1 0 n1 AC 1m
* SAME_NODE_SKIPPED Capacitor both_on=n1

.op
.end
