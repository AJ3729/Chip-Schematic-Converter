* Auto-generated SPICE netlist (NO TEXT OCR USED)

E1 0 0 0 0 100k
C1 0 n1 1u

.op
.end
