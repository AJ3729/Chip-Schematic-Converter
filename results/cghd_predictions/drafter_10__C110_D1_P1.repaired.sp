* Auto-generated SPICE netlist (NO TEXT OCR USED)

R1 0 n1 1k
L1 0 n1 1m
C1 0 n1 1u
V1 0 n1 AC 1

.op
.end
