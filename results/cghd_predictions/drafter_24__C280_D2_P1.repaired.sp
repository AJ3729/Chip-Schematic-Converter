* Auto-generated SPICE netlist (NO TEXT OCR USED)

Q1 0 0 0 QPNPdefault
.model QPNPdefault PNP

.op
.end
