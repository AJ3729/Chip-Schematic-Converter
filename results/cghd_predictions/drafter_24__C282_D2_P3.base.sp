* Auto-generated SPICE netlist (NO TEXT OCR USED)

* SAME_NODE_SKIPPED V-DC (one port) both_on=0
M1 0 0 0 0 NMOSdefault
.model NMOSdefault NMOS

.op
.end
