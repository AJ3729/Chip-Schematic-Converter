* Auto-generated SPICE netlist (NO TEXT OCR USED)

V1 n5 n1 DC 5
I1 n4 n2 AC 1m
R1 n4 0 1k
R2 n6 n7 1k
C1 n7 0 1u
R3 n6 0 1k
C2 n2 n3 1u
C3 0 n4 1u
R4 n1 n4 1k
R5 n1 n2 1k
* SAME_NODE_SKIPPED V-DC (one port) both_on=0

.op
.end
