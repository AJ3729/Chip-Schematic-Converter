* Auto-generated SPICE netlist (NO TEXT OCR USED)

E1 0 0 0 0 100k
C1 0 n2 1u
M1 n1 n1 n1 n1 PMOSdefault
.model PMOSdefault PMOS

.op
.end
