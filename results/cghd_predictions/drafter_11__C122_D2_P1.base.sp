* Auto-generated SPICE netlist (NO TEXT OCR USED)

L1 n4 n3 1m
M1 n1 n2 0 0 NMOSdefault
C1 0 n3 1u
M2 0 0 n5 n5 NMOSdefault
.model NMOSdefault NMOS

.op
.end
