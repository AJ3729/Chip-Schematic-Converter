* Auto-generated SPICE netlist (NO TEXT OCR USED)

C1 0 n1 1u

.op
.end
