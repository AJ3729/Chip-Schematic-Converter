* Auto-generated SPICE netlist (NO TEXT OCR USED)

* SAME_NODE_SKIPPED V-AC both_on=0
R1 n1 0 1k
D1 0 n1 Zdefault
D2 n1 0 Zdefault
C1 n1 0 1u
.model Zdefault D(bv=5.1)

.op
.end
