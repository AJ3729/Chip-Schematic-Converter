* Auto-generated SPICE netlist (NO TEXT OCR USED)

C1 0 n1 1u
R1 n1 n2 1k
R2 0 n2 1k

.op
.end
