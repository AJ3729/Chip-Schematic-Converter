* Auto-generated SPICE netlist (NO TEXT OCR USED)

R1 0 n6 1k
C1 n4 n6 1u
C2 n3 n2 1u
R2 n6 n3 1k
R3 0 n4 1k
R4 n1 n2 1k
C3 0 n4 1u
R5 0 n5 1k

* --- design-intent repair (does not change topology) ---
Rshunt_n1 n1 0 1e+09
Rshunt_n5 n5 0 1e+09

.op
.end
