* Auto-generated SPICE netlist (NO TEXT OCR USED)

* UNSNAPPED BJT-NPN raw_nodes=[2, 4, None]
R1 0 n3 1k
Q1 n1 n2 0 QNPNdefault
.model QNPNdefault NPN

.op
.end
