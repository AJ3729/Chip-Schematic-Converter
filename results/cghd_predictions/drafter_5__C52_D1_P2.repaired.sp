* Auto-generated SPICE netlist (NO TEXT OCR USED)

Q1 0 0 0 QNPNdefault
* SAME_NODE_SKIPPED Capacitor both_on=0
* SAME_NODE_SKIPPED Capacitor both_on=0
.model QNPNdefault NPN

.op
.end
