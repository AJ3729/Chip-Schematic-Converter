* Auto-generated SPICE netlist (NO TEXT OCR USED)

C1 0 n2 1u
R1 n1 0 1k
C2 n1 n2 1u

.op
.end
