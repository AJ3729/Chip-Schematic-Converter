* Auto-generated SPICE netlist (NO TEXT OCR USED)

* UNSNAPPED Capacitor raw_nodes=[2, None]
* SAME_NODE_SKIPPED Capacitor both_on=0
* UNSNAPPED Capacitor raw_nodes=[2, None]
* WARNING: no valid components written

.op
.end
