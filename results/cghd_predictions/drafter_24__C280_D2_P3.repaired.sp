* Auto-generated SPICE netlist (NO TEXT OCR USED)

* UNSNAPPED MOSFET-N raw_nodes=[0, None, None]
E1 0 0 0 0 100k

.op
.end
