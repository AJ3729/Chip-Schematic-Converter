* Auto-generated SPICE netlist (NO TEXT OCR USED)

V1 0 n1 DC 5
R1 n1 n2 1k
C1 n2 n3 1u
C2 n2 0 1u
R2 n3 0 1k

.op
.end
