* Auto-generated SPICE netlist (NO TEXT OCR USED)

E1 n2 0 0 n1 100k
R1 n1 n2 1k
R2 n4 0 1k
R3 n3 n1 1k
R4 0 n5 1k

.op
.end
