* Auto-generated SPICE netlist (NO TEXT OCR USED)

R1 n2 0 1k
R2 n1 0 1k
* SAME_NODE_SKIPPED Resistor both_on=0
R3 n1 n3 1k

.op
.end
