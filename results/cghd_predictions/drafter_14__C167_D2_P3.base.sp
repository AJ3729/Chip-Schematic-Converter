* Auto-generated SPICE netlist (NO TEXT OCR USED)

* UNSNAPPED V-DC raw_nodes=[4, None]
* WARNING: no valid components written

.op
.end
