* Auto-generated SPICE netlist (NO TEXT OCR USED)

I1 n5 0 AC 1m
C1 n1 0 1u
L1 n4 n2 1m
C2 n3 0 1u
C3 n2 0 1u
L2 n1 n5 1m
C4 n3 0 1u
V1 n6 0 DC 5
R1 n2 n3 1k
L3 n2 n3 1m
L4 n1 n5 1m

.op
.end
