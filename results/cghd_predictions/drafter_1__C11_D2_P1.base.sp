* Auto-generated SPICE netlist (NO TEXT OCR USED)

C1 0 n2 1u
I1 0 n4 AC 1m
V1 n2 n5 AC 1
L1 0 n1 1m
I2 n3 n1 DC 1m
I3 n2 n5 DC 1m

.op
.end
