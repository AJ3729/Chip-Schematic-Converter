* Auto-generated SPICE netlist (NO TEXT OCR USED)

L1 0 n1 1m
R1 n3 0 1k
D1 0 n3 Ddefault
D2 0 n1 Ddefault
D3 n1 n2 Ddefault
D4 0 n1 Ddefault
D5 n1 n2 Ddefault
.model Ddefault D

.op
.end
