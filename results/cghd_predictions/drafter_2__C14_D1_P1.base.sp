* Auto-generated SPICE netlist (NO TEXT OCR USED)

M1 n1 n1 n1 n1 PMOSdefault
* SAME_NODE_SKIPPED Diode both_on=n1
* SAME_NODE_SKIPPED Zener Diode both_on=n1
D1 n2 n1 Ddefault
* SAME_NODE_SKIPPED Resistor both_on=n1
* SAME_NODE_SKIPPED Diode both_on=n1
* SAME_NODE_SKIPPED Zener Diode both_on=n1
* SAME_NODE_SKIPPED Resistor both_on=n1
.model Ddefault D
.model PMOSdefault PMOS

.op
.end
