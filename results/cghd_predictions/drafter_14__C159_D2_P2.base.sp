* Auto-generated SPICE netlist (NO TEXT OCR USED)

I1 0 n1 DC 1m

.op
.end
