* Auto-generated SPICE netlist (NO TEXT OCR USED)

* SAME_NODE_SKIPPED I-AC both_on=0
M1 0 n1 0 0 NMOSdefault
.model NMOSdefault NMOS

.op
.end
