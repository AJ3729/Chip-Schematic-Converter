* Auto-generated SPICE netlist (NO TEXT OCR USED)

* SAME_NODE_SKIPPED Diode both_on=0
Q1 n1 n2 0 QPNPdefault
* SAME_NODE_SKIPPED V-DC (one port) both_on=0
.model QPNPdefault PNP

.op
.end
