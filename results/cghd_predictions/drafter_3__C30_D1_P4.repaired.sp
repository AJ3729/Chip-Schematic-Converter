* Auto-generated SPICE netlist (NO TEXT OCR USED)

R1 0 n1 1k
D1 n1 0 Ddefault
* SAME_NODE_SKIPPED Diode both_on=0
D2 n1 0 Ddefault
D3 n1 0 Ddefault
.model Ddefault D

.op
.end
