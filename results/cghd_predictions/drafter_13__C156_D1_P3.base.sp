* Auto-generated SPICE netlist (NO TEXT OCR USED)

C1 n2 0 1u
I1 n1 0 AC 1m
R1 n1 0 1k
I2 n2 n1 DC 1m

.op
.end
