* Auto-generated SPICE netlist (NO TEXT OCR USED)

* UNSNAPPED Op-Amp raw_nodes=[2, None, None]
* WARNING: no valid components written

* --- design-intent repair (does not change topology) ---
Rshunt_n1 n1 0 1e+09

.op
.end
