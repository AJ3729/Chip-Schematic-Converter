* Auto-generated SPICE netlist (NO TEXT OCR USED)

D1 n1 0 Zdefault
M1 0 n2 0 0 PMOSdefault
C1 n1 0 1u
* SAME_NODE_SKIPPED Zener Diode both_on=0
* SAME_NODE_SKIPPED Capacitor both_on=0
.model PMOSdefault PMOS
.model Zdefault D(bv=5.1)

.op
.end
