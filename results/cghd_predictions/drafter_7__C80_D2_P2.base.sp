* Auto-generated SPICE netlist (NO TEXT OCR USED)

R1 0 n4 1k
R2 n3 0 1k
R3 n1 0 1k
* SAME_NODE_SKIPPED Resistor both_on=n2
* SAME_NODE_SKIPPED Resistor both_on=0
* SAME_NODE_SKIPPED Capacitor both_on=0

.op
.end
