* Auto-generated SPICE netlist (NO TEXT OCR USED)

I1 0 n1 AC 1m

.op
.end
