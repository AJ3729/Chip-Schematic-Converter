* Auto-generated SPICE netlist (NO TEXT OCR USED)

* UNSNAPPED BJT-NPN raw_nodes=[2, 4, None]
R1 0 n3 1k
Q1 n1 n2 0 QNPNdefault
.model QNPNdefault NPN

* --- design-intent repair (does not change topology) ---
Rshunt_n2 n2 0 1e+09
Rshunt_n3 n3 0 1e+09

.op
.end
