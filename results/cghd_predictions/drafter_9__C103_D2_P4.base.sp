* Auto-generated SPICE netlist (NO TEXT OCR USED)

* SAME_NODE_SKIPPED Resistor both_on=0
R1 0 n2 1k
C1 n1 0 1u

.op
.end
