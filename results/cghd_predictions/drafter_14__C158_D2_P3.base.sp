* Auto-generated SPICE netlist (NO TEXT OCR USED)

* SAME_NODE_SKIPPED Capacitor both_on=0
R1 n1 0 1k
C1 0 n1 1u
* SAME_NODE_SKIPPED Capacitor both_on=0

.op
.end
