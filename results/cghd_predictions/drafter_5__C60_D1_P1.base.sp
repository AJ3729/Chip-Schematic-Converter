* Auto-generated SPICE netlist (NO TEXT OCR USED)

E1 0 0 0 0 100k
C1 0 n2 1u
C2 n1 0 1u

.op
.end
