* Auto-generated SPICE netlist (NO TEXT OCR USED)

C1 n4 n5 1u
E1 n12 0 n19 n11 100k
C2 n1 n3 1u
C3 n8 n13 1u
E2 n5 0 n18 n4 100k
C4 n7 n8 1u
R1 n14 n15 1k
R2 n7 n8 1k
C5 n1 n3 1u
R3 n11 n12 1k
C6 n13 n15 1u
R4 n10 n7 1k
R5 n12 n6 1k
C7 n9 n10 1u
C8 n11 n12 1u
C9 n15 n4 1u
R6 n9 n16 1k
R7 n17 n20 1k
R8 n4 n5 1k
E3 n2 0 n4 n5 100k
E4 n7 0 0 n8 100k
* SAME_NODE_SKIPPED Inductor both_on=n21

.op
.end
