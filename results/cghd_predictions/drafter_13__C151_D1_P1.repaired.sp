* Auto-generated SPICE netlist (NO TEXT OCR USED)

L1 n2 0 1m
L2 0 n1 1m
L3 0 n1 1m
C1 0 n1 1u
L4 0 n1 1m

* --- design-intent repair (does not change topology) ---
Rshunt_n2 n2 0 1e+09

.op
.end
