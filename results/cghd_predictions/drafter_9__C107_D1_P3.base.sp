* Auto-generated SPICE netlist (NO TEXT OCR USED)

D1 0 n2 Zdefault
R1 n1 n2 1k
* SAME_NODE_SKIPPED Capacitor both_on=0
* SAME_NODE_SKIPPED Capacitor both_on=0
C1 n3 0 1u
R2 n1 0 1k
* SAME_NODE_SKIPPED Capacitor both_on=0
* SAME_NODE_SKIPPED Capacitor both_on=0
* SAME_NODE_SKIPPED Inductor both_on=0
R3 n1 0 1k
.model Zdefault D(bv=5.1)

.op
.end
