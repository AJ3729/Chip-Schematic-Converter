* Auto-generated SPICE netlist (NO TEXT OCR USED)

C1 0 n1 1u
C2 n2 n1 1u
L1 0 n1 1m
L2 n2 0 1m

.op
.end
