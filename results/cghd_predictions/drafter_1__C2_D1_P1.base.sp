* Auto-generated SPICE netlist (NO TEXT OCR USED)

R1 0 n2 1k
V1 n2 n5 DC 5
V2 n1 n3 DC 5
R2 n3 0 1k
R3 0 n2 1k
C1 0 n4 1u
C2 0 n5 1u
R4 n4 n2 1k
R5 n3 0 1k

.op
.end
