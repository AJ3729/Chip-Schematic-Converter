* Auto-generated SPICE netlist (NO TEXT OCR USED)

V1 0 n1 DC 5
R1 0 n2 1k
R2 n1 n2 1k

.op
.end
