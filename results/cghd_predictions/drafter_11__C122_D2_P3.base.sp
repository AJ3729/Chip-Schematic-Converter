* Auto-generated SPICE netlist (NO TEXT OCR USED)

L1 0 n2 1m
L2 n4 0 1m
C1 0 n2 1u
C2 n2 n4 1u
V1 n1 n3 AC 1

.op
.end
