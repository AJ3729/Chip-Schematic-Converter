* Auto-generated SPICE netlist (NO TEXT OCR USED)

I1 n1 n3 AC 1m
R1 n1 n2 1k
R2 0 n3 1k
R3 0 n3 1k
R4 0 n2 1k
D1 n2 0 Zdefault
.model Zdefault D(bv=5.1)

.op
.end
