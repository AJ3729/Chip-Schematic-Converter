* Auto-generated SPICE netlist (NO TEXT OCR USED)

C1 n3 0 1u
I1 0 n3 DC 1m
I2 n2 0 DC 1m
E1 n1 0 n1 n1 100k

.op
.end
