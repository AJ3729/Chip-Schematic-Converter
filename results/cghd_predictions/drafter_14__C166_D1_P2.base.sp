* Auto-generated SPICE netlist (NO TEXT OCR USED)

R1 n1 0 1k
C1 n2 0 1u
* SAME_NODE_SKIPPED I-DC both_on=0

.op
.end
