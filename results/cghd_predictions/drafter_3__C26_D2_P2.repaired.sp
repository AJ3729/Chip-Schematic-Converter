* Auto-generated SPICE netlist (NO TEXT OCR USED)

D1 n1 0 Zdefault
* SAME_NODE_SKIPPED Capacitor both_on=0
.model Zdefault D(bv=5.1)

* --- design-intent repair (does not change topology) ---
Rshunt_n1 n1 0 1e+09

.op
.end
