* Auto-generated SPICE netlist (NO TEXT OCR USED)

* SAME_NODE_SKIPPED V-DC both_on=0
* SAME_NODE_SKIPPED Capacitor both_on=0
C1 0 n1 1u
C2 0 n1 1u

* --- design-intent repair (does not change topology) ---
Rshunt_n1 n1 0 1e+09

.op
.end
