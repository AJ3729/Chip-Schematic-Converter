* Auto-generated SPICE netlist (NO TEXT OCR USED)

R1 n12 n20 1k
C1 n5 n12 1u
C2 n11 n14 1u
C3 n3 n7 1u
R2 n3 n7 1k
R3 n6 n5 1k
R4 n20 n23 1k
R5 n11 n19 1k
C4 n6 n5 1u
C5 n12 n17 1u
C6 n17 n3 1u
R6 n7 n8 1k
E1 n7 0 n21 n15 100k
C7 n7 n8 1u
C8 n1 n2 1u
R7 n10 n5 1k
E2 n6 0 n5 n10 100k
R8 n16 0 1k
L1 n9 n14 1m
R9 n9 n14 1k
C9 n12 n3 1u
E3 n18 0 n7 n13 100k
R10 n3 n4 1k
* SAME_NODE_SKIPPED Resistor both_on=n7
R11 n4 n7 1k
L2 n8 n18 1m

.op
.end
