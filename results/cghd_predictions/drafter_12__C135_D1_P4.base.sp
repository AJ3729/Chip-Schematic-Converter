* Auto-generated SPICE netlist (NO TEXT OCR USED)

* SAME_NODE_SKIPPED V-AC both_on=n1
* SAME_NODE_SKIPPED Resistor both_on=n1
* WARNING: no valid components written

.op
.end
