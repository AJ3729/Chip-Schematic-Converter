* Auto-generated SPICE netlist (NO TEXT OCR USED)

V1 0 n1 AC 1
L1 0 n1 1m
R1 0 n1 1k
C1 0 n1 1u
V2 0 n1 AC 1

.op
.end
