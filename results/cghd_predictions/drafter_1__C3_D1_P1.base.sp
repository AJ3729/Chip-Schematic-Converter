* Auto-generated SPICE netlist (NO TEXT OCR USED)

V1 n2 0 DC 5
R1 n1 0 1k
C1 n1 n2 1u
R2 n1 0 1k

.op
.end
