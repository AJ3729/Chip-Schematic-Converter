* Auto-generated SPICE netlist (NO TEXT OCR USED)

* SAME_NODE_SKIPPED V-DC (one port) both_on=0
Q1 n1 0 n1 QPNPdefault
.model QPNPdefault PNP

.op
.end
