* Auto-generated SPICE netlist (NO TEXT OCR USED)

D1 n4 n2 Zdefault
C1 n1 n3 1u
.model Zdefault D(bv=5.1)

.op
.end
