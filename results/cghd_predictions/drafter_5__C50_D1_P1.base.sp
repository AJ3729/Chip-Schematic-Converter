* Auto-generated SPICE netlist (NO TEXT OCR USED)

* UNSNAPPED Capacitor raw_nodes=[0, None]
C1 0 n1 1u
* SAME_NODE_SKIPPED Capacitor both_on=0

.op
.end
