* Auto-generated SPICE netlist (NO TEXT OCR USED)

C1 0 n1 1u
* SAME_NODE_SKIPPED Zener Diode both_on=0
C2 n1 0 1u
* SAME_NODE_SKIPPED Diode both_on=0

.op
.end
