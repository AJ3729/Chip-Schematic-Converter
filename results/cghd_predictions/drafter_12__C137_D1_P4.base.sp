* Auto-generated SPICE netlist (NO TEXT OCR USED)

C1 n1 0 1u
R1 0 n3 1k
R2 n2 n1 1k
C2 n2 n3 1u
R3 0 n3 1k

.op
.end
