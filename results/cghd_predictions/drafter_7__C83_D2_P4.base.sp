* Auto-generated SPICE netlist (NO TEXT OCR USED)

I1 n2 0 AC 1m
R1 n1 0 1k
R2 n3 n4 1k
R3 n5 n6 1k
R4 n1 n3 1k
I2 0 n6 AC 1m
I3 n4 n3 AC 1m
R5 n1 n2 1k

.op
.end
