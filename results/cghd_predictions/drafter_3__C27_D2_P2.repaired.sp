* Auto-generated SPICE netlist (NO TEXT OCR USED)

C1 n2 n1 1u
R1 n1 0 1k

* --- design-intent repair (does not change topology) ---
Rshunt_n2 n2 0 1e+09

.op
.end
