* Auto-generated SPICE netlist (NO TEXT OCR USED)

R1 n2 n1 1k
C1 n1 0 1u
V1 0 n2 DC 5

.op
.end
