* Auto-generated SPICE netlist (NO TEXT OCR USED)

C1 0 n1 1u
* UNSNAPPED Capacitor raw_nodes=[2, None]

.op
.end
