* Auto-generated SPICE netlist (NO TEXT OCR USED)

I1 n1 n3 AC 1m
R1 n1 0 1k
R2 n2 0 1k
R3 n2 n3 1k
R4 n2 n3 1k
D1 0 n2 Zdefault
* SAME_NODE_SKIPPED Resistor both_on=0
.model Zdefault D(bv=5.1)

.op
.end
