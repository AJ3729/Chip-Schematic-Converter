* Auto-generated SPICE netlist (NO TEXT OCR USED)

Q1 n6 n7 n9 QNPNdefault
Q2 n7 n7 n9 QNPNdefault
Q3 0 n5 n9 QNPNdefault
C1 n5 n3 1u
Q4 n1 n8 n6 QNPNdefault
Q5 n3 n4 n11 QNPNdefault
Q6 n4 n7 n12 QNPNdefault
Q7 0 n1 n6 QNPNdefault
Q8 0 n3 n5 QPNPdefault
R1 n8 n10 1k
R2 n3 0 1k
R3 n5 n9 1k
C2 n4 0 1u
R4 n1 n8 1k
R5 0 n7 1k
R6 n12 n9 1k
R7 n11 n9 1k
Q9 n2 n3 n2 QPNPdefault
Q10 0 n1 0 QPNPdefault
R8 0 n1 1k
Q11 n10 n9 n10 QPNPdefault
Q12 0 n1 0 QPNPdefault
Q13 n4 0 0 QPNPdefault
.model QNPNdefault NPN
.model QPNPdefault PNP

.op
.end
