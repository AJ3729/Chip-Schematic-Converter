* Auto-generated SPICE netlist (NO TEXT OCR USED)

E1 0 0 0 0 100k

.op
.end
