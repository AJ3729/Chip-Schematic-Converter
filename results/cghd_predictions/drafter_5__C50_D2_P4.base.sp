* Auto-generated SPICE netlist (NO TEXT OCR USED)

* UNSNAPPED Capacitor raw_nodes=[3, None]
* UNSNAPPED Capacitor raw_nodes=[3, None]
Q1 0 0 0 QNPNdefault
.model QNPNdefault NPN

.op
.end
