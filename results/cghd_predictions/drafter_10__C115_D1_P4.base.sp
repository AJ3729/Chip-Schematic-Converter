* Auto-generated SPICE netlist (NO TEXT OCR USED)

R1 0 n1 1k
C1 n1 n2 1u
C2 0 n2 1u
C3 0 n2 1u

.op
.end
