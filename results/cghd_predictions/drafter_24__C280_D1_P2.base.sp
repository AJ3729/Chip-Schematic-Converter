* Auto-generated SPICE netlist (NO TEXT OCR USED)

* UNSNAPPED Op-Amp raw_nodes=[2, None, None]
* WARNING: no valid components written

.op
.end
