* Auto-generated SPICE netlist (NO TEXT OCR USED)

C1 0 n3 1u
L1 n2 0 1m
L2 0 n3 1m
C2 n1 n2 1u

.op
.end
