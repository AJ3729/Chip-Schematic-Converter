* Auto-generated SPICE netlist (NO TEXT OCR USED)

I1 n1 0 AC 1m
I2 n2 0 AC 1m
I3 0 n2 AC 1m

.op
.end
