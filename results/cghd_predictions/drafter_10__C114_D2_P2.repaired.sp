* Auto-generated SPICE netlist (NO TEXT OCR USED)

V1 0 n2 AC 1
R1 0 n1 1k
C1 n1 n2 1u

.op
.end
