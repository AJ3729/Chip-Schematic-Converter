* Auto-generated SPICE netlist (NO TEXT OCR USED)

I1 n3 n5 AC 1m
C1 n1 n5 1u
C2 n1 0 1u
R1 n1 n7 1k
C3 n2 n4 1u
R2 n6 n5 1k

.op
.end
