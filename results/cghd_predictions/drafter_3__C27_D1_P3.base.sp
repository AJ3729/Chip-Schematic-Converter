* Auto-generated SPICE netlist (NO TEXT OCR USED)

C1 n2 n4 1u
C2 n5 n6 1u
R1 n5 n3 1k
R2 n5 n7 1k
R3 n4 0 1k
R4 n1 n3 1k
* UNSNAPPED Capacitor raw_nodes=[2, None]
D1 n5 n4 Zdefault
.model Zdefault D(bv=5.1)

.op
.end
