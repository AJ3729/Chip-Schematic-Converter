* Auto-generated SPICE netlist (NO TEXT OCR USED)

V1 0 n3 DC 5
C1 0 n2 1u
R1 n1 0 1k
* SAME_NODE_SKIPPED Resistor both_on=0

* --- design-intent repair (does not change topology) ---
Rshunt_n1 n1 0 1e+09
Rshunt_n2 n2 0 1e+09
Rshunt_n3 n3 0 1e+09

.op
.end
