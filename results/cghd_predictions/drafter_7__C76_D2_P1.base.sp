* Auto-generated SPICE netlist (NO TEXT OCR USED)

Q1 0 0 0 QNPNdefault
R1 0 n1 1k
* SAME_NODE_SKIPPED V-DC (one port) both_on=0
.model QNPNdefault NPN

.op
.end
