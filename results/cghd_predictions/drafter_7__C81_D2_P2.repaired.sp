* Auto-generated SPICE netlist (NO TEXT OCR USED)

* SAME_NODE_SKIPPED Resistor both_on=0
* SAME_NODE_SKIPPED Resistor both_on=0
* SAME_NODE_SKIPPED Capacitor both_on=0
R1 0 n2 1k
R2 n1 0 1k
R3 n1 0 1k
R4 0 n2 1k
R5 0 n2 1k

.op
.end
