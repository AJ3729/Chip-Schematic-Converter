* Auto-generated SPICE netlist (NO TEXT OCR USED)

I1 0 n1 DC 1m
* SAME_NODE_SKIPPED Zener Diode both_on=0
I2 n1 0 AC 1m

.op
.end
