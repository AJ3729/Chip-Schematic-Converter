* Auto-generated SPICE netlist (NO TEXT OCR USED)

V1 n1 0 AC 1
R1 0 n3 1k
R2 n1 n3 1k
R3 0 n2 1k
C1 0 n1 1u

* --- design-intent repair (does not change topology) ---
Rshunt_n2 n2 0 1e+09

.op
.end
