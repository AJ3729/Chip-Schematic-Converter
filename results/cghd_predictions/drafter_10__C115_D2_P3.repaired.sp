* Auto-generated SPICE netlist (NO TEXT OCR USED)

C1 0 n3 1u
R1 n2 n1 1k
C2 n2 n3 1u
L1 n1 0 1m

* --- design-intent repair (does not change topology) ---
Rshunt_n3 n3 0 1e+09

.op
.end
