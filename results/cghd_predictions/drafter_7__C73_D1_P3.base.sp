* Auto-generated SPICE netlist (NO TEXT OCR USED)

Q1 0 n2 n4 QNPNdefault
R1 0 n1 1k
R2 n3 n2 1k
R3 n6 n7 1k
Q2 n8 n10 n9 QNPNdefault
Q3 n4 n7 n8 QNPNdefault
R4 n11 n10 1k
Q4 n5 0 n9 QNPNdefault
R5 n1 n5 1k
.model QNPNdefault NPN

.op
.end
