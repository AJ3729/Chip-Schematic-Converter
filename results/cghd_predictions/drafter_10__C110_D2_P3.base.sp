* Auto-generated SPICE netlist (NO TEXT OCR USED)

V1 0 n1 AC 1
R1 0 n1 1k
C1 0 n1 1u
L1 0 n1 1m

.op
.end
