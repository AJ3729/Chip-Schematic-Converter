* Auto-generated SPICE netlist (NO TEXT OCR USED)

* SAME_NODE_SKIPPED Capacitor both_on=0
* UNSNAPPED Zener Diode raw_nodes=[0, None]
* SAME_NODE_SKIPPED Zener Diode both_on=0
* SAME_NODE_SKIPPED Diode both_on=0
* WARNING: no valid components written

.op
.end
