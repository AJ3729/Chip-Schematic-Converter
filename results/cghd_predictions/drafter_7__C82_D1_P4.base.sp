* Auto-generated SPICE netlist (NO TEXT OCR USED)

* SAME_NODE_SKIPPED Resistor both_on=0
R1 0 n2 1k
Q1 0 n1 0 QNPNdefault
R2 0 n2 1k
R3 n1 0 1k
.model QNPNdefault NPN

.op
.end
