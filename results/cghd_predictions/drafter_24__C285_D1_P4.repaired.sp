* Auto-generated SPICE netlist (NO TEXT OCR USED)

M1 0 0 0 0 PMOSdefault
.model PMOSdefault PMOS

.op
.end
