* Auto-generated SPICE netlist (NO TEXT OCR USED)

M1 0 0 0 0 NMOSdefault
M2 0 0 0 0 PMOSdefault
.model NMOSdefault NMOS
.model PMOSdefault PMOS

.op
.end
