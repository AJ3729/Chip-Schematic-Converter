* Auto-generated SPICE netlist (NO TEXT OCR USED)

I1 n2 n1 DC 1m
C1 n2 n3 1u
R1 n2 n1 1k
C2 0 n4 1u

.op
.end
