* Auto-generated SPICE netlist (NO TEXT OCR USED)

R1 0 n2 1k
I1 n3 0 AC 1m
I2 n2 0 DC 1m
R2 n3 0 1k
R3 n1 0 1k
L1 n1 0 1m

.op
.end
