* Auto-generated SPICE netlist (NO TEXT OCR USED)

E1 0 0 n1 n1 100k
* UNSNAPPED MOSFET-N raw_nodes=[2, 3, None]

.op
.end
