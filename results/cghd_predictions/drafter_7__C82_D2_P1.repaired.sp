* Auto-generated SPICE netlist (NO TEXT OCR USED)

R1 n1 0 1k
Q1 0 0 n3 QPNPdefault
C1 n1 0 1u
R2 n2 n3 1k
R3 n1 n4 1k
R4 0 n4 1k
R5 n2 n1 1k
.model QPNPdefault PNP

.op
.end
