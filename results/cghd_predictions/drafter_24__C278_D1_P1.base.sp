* Auto-generated SPICE netlist (NO TEXT OCR USED)

E1 0 0 0 0 100k
Q1 n1 n2 0 QPNPdefault
.model QPNPdefault PNP

.op
.end
