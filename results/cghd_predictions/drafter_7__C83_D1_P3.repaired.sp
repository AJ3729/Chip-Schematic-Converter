* Auto-generated SPICE netlist (NO TEXT OCR USED)

R1 0 n1 1k
* SAME_NODE_SKIPPED Resistor both_on=0
I1 0 n1 AC 1m
I2 0 n1 DC 1m

.op
.end
