* Auto-generated SPICE netlist (NO TEXT OCR USED)

V1 0 n2 DC 5
C1 n1 n3 1u
R1 0 n1 1k

* --- design-intent repair (does not change topology) ---
Rshunt_n2 n2 0 1e+09
Rshunt_n3 n3 0 1e+09

.op
.end
