* Auto-generated SPICE netlist (NO TEXT OCR USED)

V1 n4 n2 DC 5
R1 n3 n4 1k
R2 n2 n3 1k
* SAME_NODE_SKIPPED I-DC both_on=n1
* SAME_NODE_SKIPPED I-DC both_on=0
* SAME_NODE_SKIPPED V-AC both_on=0

.op
.end
