* Auto-generated SPICE netlist (NO TEXT OCR USED)

I1 n1 0 AC 1m
L1 n2 0 1m

* --- design-intent repair (does not change topology) ---
Rshunt_n1 n1 0 1e+09
Rshunt_n2 n2 0 1e+09

.op
.end
