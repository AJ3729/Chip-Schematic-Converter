* Auto-generated SPICE netlist (NO TEXT OCR USED)

R1 0 n4 1k
R2 n2 0 1k
R3 n5 0 1k
R4 0 n4 1k
R5 n1 n3 1k
R6 0 n2 1k
R7 0 n1 1k
* SAME_NODE_SKIPPED Resistor both_on=0
* SAME_NODE_SKIPPED Resistor both_on=0

* --- design-intent repair (does not change topology) ---
Rshunt_n3 n3 0 1e+09
Rshunt_n5 n5 0 1e+09

.op
.end
