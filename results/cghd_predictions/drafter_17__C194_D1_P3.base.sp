* Auto-generated SPICE netlist (NO TEXT OCR USED)

E1 n10 0 n7 n11 100k
C1 n4 n6 1u
R1 n1 n3 1k
R2 n8 n3 1k
R3 n7 n2 1k
C2 n6 n8 1u
R4 n4 n3 1k
R5 n6 n3 1k
R6 n9 n8 1k
C3 n3 n13 1u
R7 n9 0 1k
R8 n7 0 1k
R9 n2 n9 1k
C4 n9 0 1u
C5 n3 n4 1u
R10 n11 0 1k
E2 n3 0 n9 n8 100k
D1 n2 n5 Ddefault
C6 n2 n5 1u
C7 n1 n3 1u
V1 n13 0 DC 5
R11 n10 n9 1k
C8 n12 0 1u
.model Ddefault D

.op
.end
