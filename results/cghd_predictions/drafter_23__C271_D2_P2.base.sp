* Auto-generated SPICE netlist (NO TEXT OCR USED)

I1 n3 0 AC 1m
* SAME_NODE_SKIPPED Capacitor both_on=0
I2 0 n2 AC 1m
R1 n2 n3 1k
C1 n1 0 1u
* SAME_NODE_SKIPPED Resistor both_on=0
C2 0 n2 1u
R2 0 n1 1k
* SAME_NODE_SKIPPED Resistor both_on=0
* SAME_NODE_SKIPPED Resistor both_on=0
* SAME_NODE_SKIPPED Resistor both_on=0
* SAME_NODE_SKIPPED Resistor both_on=0
* SAME_NODE_SKIPPED Resistor both_on=0
* SAME_NODE_SKIPPED Resistor both_on=0
* SAME_NODE_SKIPPED Capacitor both_on=0
* SAME_NODE_SKIPPED Capacitor both_on=0
* SAME_NODE_SKIPPED Capacitor both_on=0
E1 0 0 0 0 100k
* SAME_NODE_SKIPPED Capacitor both_on=0
E2 0 0 0 0 100k
M1 0 0 0 0 NMOSdefault
* SAME_NODE_SKIPPED Capacitor both_on=0
.model NMOSdefault NMOS

.op
.end
