* Auto-generated SPICE netlist (NO TEXT OCR USED)

M1 0 n1 0 0 PMOSdefault
.model PMOSdefault PMOS

.op
.end
