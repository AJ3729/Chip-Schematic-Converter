* Auto-generated SPICE netlist (NO TEXT OCR USED)

V1 0 n1 DC 5
I1 0 n1 AC 1m

.op
.end
