* Auto-generated SPICE netlist (NO TEXT OCR USED)

I1 n1 0 DC 1m
Q1 0 n1 n1 QPNPdefault
R1 n1 0 1k
R2 0 n1 1k
.model QPNPdefault PNP

.op
.end
