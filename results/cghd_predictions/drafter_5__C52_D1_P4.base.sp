* Auto-generated SPICE netlist (NO TEXT OCR USED)

* SAME_NODE_SKIPPED Capacitor both_on=0
* SAME_NODE_SKIPPED Capacitor both_on=0
Q1 n1 0 0 QNPNdefault
C1 n1 0 1u
.model QNPNdefault NPN

.op
.end
