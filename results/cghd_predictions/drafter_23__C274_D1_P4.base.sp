* Auto-generated SPICE netlist (NO TEXT OCR USED)

C1 n1 0 1u
D1 n2 n1 Zdefault
* SAME_NODE_SKIPPED Inductor both_on=0
* SAME_NODE_SKIPPED Diode both_on=0
D2 0 n2 Zdefault
.model Zdefault D(bv=5.1)

.op
.end
