* Auto-generated SPICE netlist (NO TEXT OCR USED)

M1 0 n1 0 0 PMOSdefault
.model PMOSdefault PMOS

* --- design-intent repair (does not change topology) ---
Rshunt_n1 n1 0 1e+09

.op
.end
