* Auto-generated SPICE netlist (NO TEXT OCR USED)

E1 0 0 0 0 100k
C1 0 n2 1u
M1 n1 n1 n1 n1 PMOSdefault
.model PMOSdefault PMOS

* --- design-intent repair (does not change topology) ---
Rshunt_n1 n1 0 1e+09
Rshunt_n2 n2 0 1e+09

.op
.end
