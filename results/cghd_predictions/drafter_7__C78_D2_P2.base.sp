* Auto-generated SPICE netlist (NO TEXT OCR USED)

R1 n1 0 1k
* SAME_NODE_SKIPPED Resistor both_on=0
R2 n2 0 1k
R3 0 n3 1k
* SAME_NODE_SKIPPED Capacitor both_on=0

.op
.end
