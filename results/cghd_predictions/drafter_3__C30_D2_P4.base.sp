* Auto-generated SPICE netlist (NO TEXT OCR USED)

L1 n1 0 1m
R1 n2 0 1k
D1 0 n1 Ddefault
D2 0 n2 Ddefault
D3 n1 n2 Ddefault
* SAME_NODE_SKIPPED Diode both_on=0
D4 0 n2 Ddefault
.model Ddefault D

.op
.end
