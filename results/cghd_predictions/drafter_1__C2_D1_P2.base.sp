* Auto-generated SPICE netlist (NO TEXT OCR USED)

C1 0 n6 1u
V1 n5 n6 DC 5
R1 n3 n5 1k
R2 0 n5 1k
V2 n1 n2 DC 5
R3 n2 n1 1k
R4 n4 n5 1k
C2 n3 n4 1u
D1 n1 0 Ddefault
R5 n2 0 1k
.model Ddefault D

.op
.end
