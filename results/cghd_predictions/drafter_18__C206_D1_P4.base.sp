* Auto-generated SPICE netlist (NO TEXT OCR USED)

D1 n1 0 Zdefault
* SAME_NODE_SKIPPED Capacitor both_on=0
* SAME_NODE_SKIPPED Inductor both_on=0
.model Zdefault D(bv=5.1)

.op
.end
