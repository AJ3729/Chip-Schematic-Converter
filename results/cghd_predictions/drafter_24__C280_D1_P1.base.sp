* Auto-generated SPICE netlist (NO TEXT OCR USED)

E1 0 0 0 0 100k
M1 0 0 0 0 PMOSdefault
.model PMOSdefault PMOS

.op
.end
