* Auto-generated SPICE netlist (NO TEXT OCR USED)

R1 0 n3 1k
R2 n1 n2 1k
C1 n2 0 1u
R3 0 n3 1k
C2 n1 n3 1u

.op
.end
