* Auto-generated SPICE netlist (NO TEXT OCR USED)

C1 n2 0 1u
R1 n1 0 1k
I1 n1 n2 DC 1m
* SAME_NODE_SKIPPED Resistor both_on=0

.op
.end
