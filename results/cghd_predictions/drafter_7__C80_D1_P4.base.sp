* Auto-generated SPICE netlist (NO TEXT OCR USED)

R1 n1 0 1k
R2 n2 0 1k
R3 0 n3 1k

.op
.end
