* Auto-generated SPICE netlist (NO TEXT OCR USED)

C1 n4 0 1u
R1 n3 n4 1k
Q1 n2 n4 n5 QNPNdefault
* UNSNAPPED Inductor raw_nodes=[None, None]
R2 n1 n2 1k
.model QNPNdefault NPN

.op
.end
