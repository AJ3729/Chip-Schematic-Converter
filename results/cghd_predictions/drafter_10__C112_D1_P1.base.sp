* Auto-generated SPICE netlist (NO TEXT OCR USED)

* SAME_NODE_SKIPPED V-AC both_on=0
C1 n1 0 1u
R1 n1 0 1k
R2 0 n1 1k
R3 0 n1 1k

.op
.end
