* Auto-generated SPICE netlist (NO TEXT OCR USED)

* SAME_NODE_SKIPPED V-DC (one port) both_on=0
* SAME_NODE_SKIPPED V-DC (one port) both_on=0
* SAME_NODE_SKIPPED V-DC (one port) both_on=0
* WARNING: no valid components written

.op
.end
