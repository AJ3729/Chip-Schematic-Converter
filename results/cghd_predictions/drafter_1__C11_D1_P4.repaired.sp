* Auto-generated SPICE netlist (NO TEXT OCR USED)

V1 n3 0 AC 1
C1 n2 n1 1u
C2 n2 0 1u
R1 n3 n2 1k
R2 n1 0 1k

.op
.end
