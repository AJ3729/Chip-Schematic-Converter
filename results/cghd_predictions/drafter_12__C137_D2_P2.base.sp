* Auto-generated SPICE netlist (NO TEXT OCR USED)

R1 n1 n2 1k
C1 n2 0 1u
R2 0 n3 1k
R3 0 n4 1k

.op
.end
