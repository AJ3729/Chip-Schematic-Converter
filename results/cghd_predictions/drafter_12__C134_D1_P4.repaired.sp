* Auto-generated SPICE netlist (NO TEXT OCR USED)

V1 0 n3 AC 1
R1 0 n1 1k
L1 n3 n2 1m
C1 n1 n2 1u

.op
.end
