* Auto-generated SPICE netlist (NO TEXT OCR USED)

V1 n2 0 AC 1
V2 n1 0 AC 1
* SAME_NODE_SKIPPED V-AC both_on=0
M1 0 n3 0 0 NMOSdefault
C1 n4 0 1u
.model NMOSdefault NMOS

.op
.end
