* Auto-generated SPICE netlist (NO TEXT OCR USED)

V1 0 n2 DC 5
R1 n1 n2 1k
C1 n1 0 1u

.op
.end
