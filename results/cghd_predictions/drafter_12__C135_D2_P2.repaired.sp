* Auto-generated SPICE netlist (NO TEXT OCR USED)

V1 n1 0 AC 1
C1 n1 0 1u
C2 0 n1 1u
I1 n1 0 AC 1m
* SAME_NODE_SKIPPED Capacitor both_on=0

.op
.end
