* Auto-generated SPICE netlist (NO TEXT OCR USED)

* SAME_NODE_SKIPPED Resistor both_on=0
C1 n2 n1 1u
R1 n1 n3 1k

.op
.end
