* Auto-generated SPICE netlist (NO TEXT OCR USED)

I1 n4 0 AC 1m
C1 n3 0 1u
C2 n3 n1 1u
R1 n2 n3 1k
R2 n1 0 1k

.op
.end
