* Auto-generated SPICE netlist (NO TEXT OCR USED)

R1 0 n4 1k
R2 0 n2 1k
R3 n3 n5 1k
R4 n4 n5 1k
C1 0 n2 1u
* UNSNAPPED Resistor raw_nodes=[1, None]
* SAME_NODE_SKIPPED Zener Diode both_on=n3

.op
.end
