* Auto-generated SPICE netlist (NO TEXT OCR USED)

I1 n4 n7 AC 1m
C1 n2 n6 1u
C2 n3 n8 1u
R1 n3 n10 1k
C3 0 n5 1u
* SAME_NODE_SKIPPED Inductor both_on=n2
* SAME_NODE_SKIPPED Capacitor both_on=n1
R2 n6 n9 1k

.op
.end
