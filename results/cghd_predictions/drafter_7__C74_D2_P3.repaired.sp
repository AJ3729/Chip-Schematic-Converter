* Auto-generated SPICE netlist (NO TEXT OCR USED)

R1 n2 0 1k
R2 0 n1 1k

* --- design-intent repair (does not change topology) ---
Rshunt_n1 n1 0 1e+09
Rshunt_n2 n2 0 1e+09

.op
.end
