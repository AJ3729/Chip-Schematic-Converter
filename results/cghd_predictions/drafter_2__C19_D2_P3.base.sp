* Auto-generated SPICE netlist (NO TEXT OCR USED)

I1 0 n3 DC 1m
* SAME_NODE_SKIPPED Capacitor both_on=0
R1 0 n2 1k
C1 n1 0 1u
D1 0 n2 Zdefault
* SAME_NODE_SKIPPED Capacitor both_on=0
.model Zdefault D(bv=5.1)

.op
.end
