* Auto-generated SPICE netlist (NO TEXT OCR USED)

* SAME_NODE_SKIPPED Resistor both_on=0
* SAME_NODE_SKIPPED Capacitor both_on=0
E1 0 0 0 0 100k
* SAME_NODE_SKIPPED Capacitor both_on=0
M1 0 0 0 0 PMOSdefault
* SAME_NODE_SKIPPED Capacitor both_on=0
* SAME_NODE_SKIPPED Capacitor both_on=0
* SAME_NODE_SKIPPED Capacitor both_on=0
* SAME_NODE_SKIPPED Capacitor both_on=0
.model PMOSdefault PMOS

.op
.end
