* Auto-generated SPICE netlist (NO TEXT OCR USED)

* SAME_NODE_SKIPPED Capacitor both_on=0
Q1 n1 n1 0 QNPNdefault
* SAME_NODE_SKIPPED Capacitor both_on=n1
C1 n1 0 1u
.model QNPNdefault NPN

.op
.end
