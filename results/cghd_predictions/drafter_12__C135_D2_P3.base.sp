* Auto-generated SPICE netlist (NO TEXT OCR USED)

* SAME_NODE_SKIPPED V-DC both_on=0
* SAME_NODE_SKIPPED Capacitor both_on=0
C1 0 n1 1u
C2 0 n1 1u

.op
.end
