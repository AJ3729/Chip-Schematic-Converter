* Auto-generated SPICE netlist (NO TEXT OCR USED)

C1 n1 0 1u
* SAME_NODE_SKIPPED Resistor both_on=n2
* SAME_NODE_SKIPPED Resistor both_on=n2
E1 0 0 0 n1 100k

.op
.end
