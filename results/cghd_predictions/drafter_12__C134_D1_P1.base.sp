* Auto-generated SPICE netlist (NO TEXT OCR USED)

V1 0 n1 AC 1
R1 0 n1 1k
V2 0 n1 AC 1

.op
.end
