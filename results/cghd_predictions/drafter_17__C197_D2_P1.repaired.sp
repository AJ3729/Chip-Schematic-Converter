* Auto-generated SPICE netlist (NO TEXT OCR USED)

* SAME_NODE_SKIPPED I-AC both_on=0
* SAME_NODE_SKIPPED Capacitor both_on=0
* SAME_NODE_SKIPPED Capacitor both_on=0
* SAME_NODE_SKIPPED Inductor both_on=0
* SAME_NODE_SKIPPED Capacitor both_on=0
* SAME_NODE_SKIPPED I-DC both_on=0
* SAME_NODE_SKIPPED Resistor both_on=0
* SAME_NODE_SKIPPED Capacitor both_on=0
* SAME_NODE_SKIPPED I-AC both_on=0
M1 0 0 0 0 PMOSdefault
* SAME_NODE_SKIPPED Capacitor both_on=0
M2 0 0 0 0 PMOSdefault
* SAME_NODE_SKIPPED Capacitor both_on=0
.model PMOSdefault PMOS

.op
.end
