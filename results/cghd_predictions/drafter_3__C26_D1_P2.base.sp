* Auto-generated SPICE netlist (NO TEXT OCR USED)

D1 n1 n2 Ddefault
R1 n2 0 1k
C1 n2 0 1u
D2 0 n2 Zdefault
.model Ddefault D
.model Zdefault D(bv=5.1)

.op
.end
