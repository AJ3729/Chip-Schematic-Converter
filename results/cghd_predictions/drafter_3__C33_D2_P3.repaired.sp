* Auto-generated SPICE netlist (NO TEXT OCR USED)

R1 n2 n4 1k
R2 n3 n2 1k
R3 n2 0 1k
R4 n5 n6 1k
R5 n4 n5 1k
R6 0 n1 1k
R7 0 n6 1k
R8 0 n5 1k
R9 n1 n6 1k
R10 n4 0 1k

* --- design-intent repair (does not change topology) ---
Rshunt_n3 n3 0 1e+09

.op
.end
