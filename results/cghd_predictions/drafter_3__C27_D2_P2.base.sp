* Auto-generated SPICE netlist (NO TEXT OCR USED)

C1 n2 n1 1u
R1 n1 0 1k

.op
.end
