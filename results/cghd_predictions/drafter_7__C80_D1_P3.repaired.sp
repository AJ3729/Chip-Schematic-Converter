* Auto-generated SPICE netlist (NO TEXT OCR USED)

R1 0 n4 1k
R2 n1 0 1k
R3 n2 0 1k
R4 n2 n3 1k
C1 n2 n3 1u
R5 0 n4 1k

* --- design-intent repair (does not change topology) ---
Rshunt_n1 n1 0 1e+09

.op
.end
