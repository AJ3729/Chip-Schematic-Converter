* Auto-generated SPICE netlist (NO TEXT OCR USED)

* SAME_NODE_SKIPPED Resistor both_on=0
* SAME_NODE_SKIPPED Resistor both_on=0
* SAME_NODE_SKIPPED Diode both_on=0
R1 0 n1 1k
* SAME_NODE_SKIPPED Capacitor both_on=0
* SAME_NODE_SKIPPED Capacitor both_on=0
* SAME_NODE_SKIPPED V-DC both_on=0
D1 n1 0 Ddefault
* SAME_NODE_SKIPPED V-DC both_on=0
* SAME_NODE_SKIPPED Diode both_on=0
.model Ddefault D

.op
.end
