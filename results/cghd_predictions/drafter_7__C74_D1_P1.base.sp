* Auto-generated SPICE netlist (NO TEXT OCR USED)

Q1 0 n3 n4 QNPNdefault
R1 n2 n3 1k
R2 n1 0 1k
.model QNPNdefault NPN

.op
.end
