* Auto-generated SPICE netlist (NO TEXT OCR USED)

C1 n1 n2 1u
* SAME_NODE_SKIPPED I-DC both_on=0

.op
.end
