* Auto-generated SPICE netlist (NO TEXT OCR USED)

E1 0 0 0 0 100k
* SAME_NODE_SKIPPED Capacitor both_on=0

.op
.end
