* Auto-generated SPICE netlist (NO TEXT OCR USED)

C1 0 n6 1u
* SAME_NODE_SKIPPED Capacitor both_on=0
I1 n7 n5 AC 1m
R1 n3 0 1k
C2 0 n4 1u
R2 n1 n2 1k

.op
.end
