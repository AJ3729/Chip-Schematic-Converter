* Auto-generated SPICE netlist (NO TEXT OCR USED)

* SAME_NODE_SKIPPED Zener Diode both_on=0
* SAME_NODE_SKIPPED Capacitor both_on=0
* SAME_NODE_SKIPPED V-DC (one port) both_on=0
* SAME_NODE_SKIPPED Zener Diode both_on=0
* SAME_NODE_SKIPPED Capacitor both_on=0
D1 n1 0 Zdefault
D2 0 n1 Ddefault
D3 0 n1 Zdefault
* SAME_NODE_SKIPPED V-DC (one port) both_on=0
.model Ddefault D
.model Zdefault D(bv=5.1)

.op
.end
