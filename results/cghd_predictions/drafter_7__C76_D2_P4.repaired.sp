* Auto-generated SPICE netlist (NO TEXT OCR USED)

R1 0 n1 1k
Q1 0 0 0 QNPNdefault
* SAME_NODE_SKIPPED Capacitor both_on=0
.model QNPNdefault NPN

* --- design-intent repair (does not change topology) ---
Rshunt_n1 n1 0 1e+09

.op
.end
