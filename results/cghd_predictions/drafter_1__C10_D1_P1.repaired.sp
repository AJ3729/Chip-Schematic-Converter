* Auto-generated SPICE netlist (NO TEXT OCR USED)

I1 n3 n1 DC 1m
R1 n1 n3 1k
L1 n1 n2 1m

* --- design-intent repair (does not change topology) ---
Rshunt_n1 n1 0 1e+09

.op
.end
