* Auto-generated SPICE netlist (NO TEXT OCR USED)

V1 n1 0 AC 1
C1 n2 0 1u
R1 n1 n2 1k

.op
.end
