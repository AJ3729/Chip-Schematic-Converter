* Auto-generated SPICE netlist (NO TEXT OCR USED)

C1 n2 0 1u
R1 n1 n2 1k
* SAME_NODE_SKIPPED Resistor both_on=0
V1 n1 0 DC 5

.op
.end
