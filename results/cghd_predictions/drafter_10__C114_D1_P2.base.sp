* Auto-generated SPICE netlist (NO TEXT OCR USED)

V1 0 n2 DC 5
C1 n1 n3 1u
R1 0 n1 1k

.op
.end
