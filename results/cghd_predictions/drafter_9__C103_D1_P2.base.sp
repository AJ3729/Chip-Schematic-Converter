* Auto-generated SPICE netlist (NO TEXT OCR USED)

R1 0 n4 1k
D1 n3 0 Zdefault
C1 n1 n2 1u
V1 n1 0 DC 5
.model Zdefault D(bv=5.1)

.op
.end
