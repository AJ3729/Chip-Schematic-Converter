* Auto-generated SPICE netlist (NO TEXT OCR USED)

V1 0 n2 AC 1
* SAME_NODE_SKIPPED Capacitor both_on=0
* SAME_NODE_SKIPPED Capacitor both_on=0
* SAME_NODE_SKIPPED Capacitor both_on=0
L1 n1 0 1m

.op
.end
