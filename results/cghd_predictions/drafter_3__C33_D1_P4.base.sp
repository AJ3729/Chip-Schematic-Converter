* Auto-generated SPICE netlist (NO TEXT OCR USED)

R1 0 n1 1k
R2 n3 n2 1k
R3 n2 0 1k
R4 n2 n6 1k
R5 n1 n4 1k
R6 n6 n5 1k
R7 n5 n4 1k
R8 0 n5 1k
R9 0 n6 1k
R10 0 n4 1k

.op
.end
