* Auto-generated SPICE netlist (NO TEXT OCR USED)

Q1 0 n1 0 QPNPdefault
R1 0 n4 1k
Q2 n3 n2 n1 QNPNdefault
.model QNPNdefault NPN
.model QPNPdefault PNP

.op
.end
