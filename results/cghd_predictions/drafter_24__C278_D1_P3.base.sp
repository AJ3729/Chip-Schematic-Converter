* Auto-generated SPICE netlist (NO TEXT OCR USED)

* SAME_NODE_SKIPPED Diode both_on=0
* SAME_NODE_SKIPPED V-DC (one port) both_on=0
E1 n1 0 n1 n1 100k

.op
.end
