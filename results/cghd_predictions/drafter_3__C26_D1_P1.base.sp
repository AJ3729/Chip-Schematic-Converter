* Auto-generated SPICE netlist (NO TEXT OCR USED)

R1 n2 0 1k
R2 0 n3 1k
C1 n2 0 1u
D1 n2 0 Ddefault
D2 n1 n2 Ddefault
.model Ddefault D

.op
.end
