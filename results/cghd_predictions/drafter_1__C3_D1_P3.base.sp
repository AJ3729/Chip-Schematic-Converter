* Auto-generated SPICE netlist (NO TEXT OCR USED)

I1 0 n2 AC 1m
C1 n1 n3 1u
C2 0 n2 1u

.op
.end
