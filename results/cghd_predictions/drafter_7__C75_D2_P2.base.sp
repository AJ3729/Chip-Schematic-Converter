* Auto-generated SPICE netlist (NO TEXT OCR USED)

* SAME_NODE_SKIPPED Diode both_on=n3
* SAME_NODE_SKIPPED Resistor both_on=0
Q1 n2 n4 0 QNPNdefault
R1 n1 n4 1k
Q2 n2 n5 0 QNPNdefault
.model QNPNdefault NPN

.op
.end
