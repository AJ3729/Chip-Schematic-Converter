* Auto-generated SPICE netlist (NO TEXT OCR USED)

V1 0 n1 DC 5
R1 n1 0 1k
R2 n1 0 1k
R3 n1 0 1k

.op
.end
