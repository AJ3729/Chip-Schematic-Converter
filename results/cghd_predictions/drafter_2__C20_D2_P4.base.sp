* Auto-generated SPICE netlist (NO TEXT OCR USED)

I1 n1 0 DC 1m
* SAME_NODE_SKIPPED Resistor both_on=0
* SAME_NODE_SKIPPED V-DC both_on=0

.op
.end
