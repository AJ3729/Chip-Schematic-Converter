* Auto-generated SPICE netlist (NO TEXT OCR USED)

I1 n4 n2 DC 1m
R1 n1 n2 1k
R2 n2 n3 1k

.op
.end
