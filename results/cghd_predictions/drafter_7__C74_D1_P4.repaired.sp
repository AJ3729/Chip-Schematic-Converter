* Auto-generated SPICE netlist (NO TEXT OCR USED)

* UNSNAPPED Resistor raw_nodes=[2, None]
R1 n2 n1 1k

* --- design-intent repair (does not change topology) ---
Rshunt_n1 n1 0 1e+09

.op
.end
