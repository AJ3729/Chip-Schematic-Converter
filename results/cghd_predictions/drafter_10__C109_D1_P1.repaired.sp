* Auto-generated SPICE netlist (NO TEXT OCR USED)

C1 0 n1 1u
R1 0 n1 1k

.op
.end
