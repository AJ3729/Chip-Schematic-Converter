* Auto-generated SPICE netlist (NO TEXT OCR USED)

R1 n3 0 1k
R2 n1 0 1k
R3 0 n2 1k

.op
.end
