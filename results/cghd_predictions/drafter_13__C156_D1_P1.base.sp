* Auto-generated SPICE netlist (NO TEXT OCR USED)

I1 0 n1 DC 1m
I2 n2 n4 AC 1m
C1 0 n2 1u
R1 n1 n2 1k
I3 0 n3 AC 1m
R2 n1 n4 1k
V1 n3 0 DC 5
I4 n2 n4 AC 1m

.op
.end
