* Auto-generated SPICE netlist (NO TEXT OCR USED)

I1 0 n2 AC 1m
C1 n1 n3 1u
C2 0 n2 1u

* --- design-intent repair (does not change topology) ---
Rshunt_n1 n1 0 1e+09
Rshunt_n2 n2 0 1e+09

.op
.end
