* Auto-generated SPICE netlist (NO TEXT OCR USED)

Q1 0 0 0 QNPNdefault
* SAME_NODE_SKIPPED Capacitor both_on=0
C1 n1 0 1u
.model QNPNdefault NPN

.op
.end
