* Auto-generated SPICE netlist (NO TEXT OCR USED)

Q1 n1 0 0 QNPNdefault
R1 n1 0 1k
* SAME_NODE_SKIPPED Resistor both_on=0
R2 0 n1 1k
C1 n1 0 1u
.model QNPNdefault NPN

.op
.end
