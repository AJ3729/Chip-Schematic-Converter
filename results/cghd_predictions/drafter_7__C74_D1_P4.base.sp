* Auto-generated SPICE netlist (NO TEXT OCR USED)

* UNSNAPPED Resistor raw_nodes=[2, None]
R1 n2 n1 1k

.op
.end
