* Auto-generated SPICE netlist (NO TEXT OCR USED)

V1 n2 0 AC 1
R1 n2 n1 1k
R2 n3 0 1k
C1 n1 n3 1u
L1 n3 0 1m

.op
.end
