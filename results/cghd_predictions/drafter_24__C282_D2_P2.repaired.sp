* Auto-generated SPICE netlist (NO TEXT OCR USED)

M1 0 0 0 0 NMOSdefault
.model NMOSdefault NMOS

.op
.end
