* Auto-generated SPICE netlist (NO TEXT OCR USED)

E1 n1 0 n1 n1 100k

.op
.end
