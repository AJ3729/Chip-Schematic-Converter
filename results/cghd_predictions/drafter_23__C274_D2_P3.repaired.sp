* Auto-generated SPICE netlist (NO TEXT OCR USED)

C1 n1 0 1u
* SAME_NODE_SKIPPED Resistor both_on=0
L1 0 n2 1m
L2 n2 0 1m
D1 0 n1 Zdefault
* SAME_NODE_SKIPPED Capacitor both_on=0
.model Zdefault D(bv=5.1)

.op
.end
