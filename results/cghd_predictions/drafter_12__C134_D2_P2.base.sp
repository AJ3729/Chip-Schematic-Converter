* Auto-generated SPICE netlist (NO TEXT OCR USED)

V1 0 n2 AC 1
R1 0 n1 1k
* SAME_NODE_SKIPPED Capacitor both_on=n3

.op
.end
