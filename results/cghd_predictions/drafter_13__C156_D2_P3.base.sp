* Auto-generated SPICE netlist (NO TEXT OCR USED)

* SAME_NODE_SKIPPED I-AC both_on=0
* SAME_NODE_SKIPPED I-AC both_on=0
* SAME_NODE_SKIPPED I-AC both_on=0
* SAME_NODE_SKIPPED I-AC both_on=0
* UNSNAPPED I-AC raw_nodes=[1, None]
* WARNING: no valid components written

.op
.end
