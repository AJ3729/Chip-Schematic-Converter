* Auto-generated SPICE netlist (NO TEXT OCR USED)

C1 n2 0 1u
V1 n1 0 AC 1
V2 n1 0 AC 1
R1 n1 n2 1k

.op
.end
