* Auto-generated SPICE netlist (NO TEXT OCR USED)

C1 n2 n4 1u
C2 0 n3 1u
I1 n2 n1 DC 1m
R1 0 n1 1k
R2 n4 n3 1k
R3 n1 n3 1k
L1 0 n2 1m
C3 n1 n3 1u
C4 n1 n3 1u

.op
.end
