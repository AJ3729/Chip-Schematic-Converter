* Auto-generated SPICE netlist (NO TEXT OCR USED)

C1 0 n6 1u
R1 n5 n4 1k
R2 0 n4 1k
C2 n3 n4 1u
V1 n2 n1 DC 5
R3 n1 0 1k
R4 n1 0 1k
D1 n3 0 Zdefault
V2 n4 n6 DC 5
.model Zdefault D(bv=5.1)

.op
.end
