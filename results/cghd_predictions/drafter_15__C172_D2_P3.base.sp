* Auto-generated SPICE netlist (NO TEXT OCR USED)

I1 n5 n9 AC 1m
* SAME_NODE_SKIPPED Capacitor both_on=n1
* SAME_NODE_SKIPPED Resistor both_on=n1
C1 n5 n6 1u
* SAME_NODE_SKIPPED Resistor both_on=n1
R1 n1 n5 1k
R2 n7 n5 1k
* SAME_NODE_SKIPPED Resistor both_on=n1
R3 n1 n2 1k
R4 n6 0 1k
* SAME_NODE_SKIPPED I-DC both_on=n1
R5 n1 n3 1k
C2 n4 n7 1u
* SAME_NODE_SKIPPED I-AC both_on=n1
* SAME_NODE_SKIPPED Capacitor both_on=n1
* SAME_NODE_SKIPPED I-DC both_on=n1
R6 n1 n8 1k

.op
.end
