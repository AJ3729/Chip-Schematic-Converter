* Auto-generated SPICE netlist (NO TEXT OCR USED)

R1 0 n1 1k
C1 0 n1 1u
L1 0 n1 1m
I1 n1 0 DC 1m

.op
.end
