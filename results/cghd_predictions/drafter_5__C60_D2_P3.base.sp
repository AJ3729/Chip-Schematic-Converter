* Auto-generated SPICE netlist (NO TEXT OCR USED)

E1 0 0 0 0 100k
I1 n3 n4 DC 1m
* SAME_NODE_SKIPPED Capacitor both_on=0
I2 n4 n2 DC 1m
* SAME_NODE_SKIPPED Resistor both_on=n1

.op
.end
