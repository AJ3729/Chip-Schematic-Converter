* Auto-generated SPICE netlist (NO TEXT OCR USED)

R1 n5 n3 1k
R2 n3 n6 1k
R3 n1 n5 1k
V1 n3 n4 DC 5
V2 n5 0 DC 5
V3 n1 0 DC 5
* UNSNAPPED V-AC raw_nodes=[1, None]

* --- design-intent repair (does not change topology) ---
Rshunt_n2 n2 0 1e+09
Rshunt_n4 n4 0 1e+09
Rshunt_n6 n6 0 1e+09

.op
.end
