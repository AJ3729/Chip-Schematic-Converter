* Auto-generated SPICE netlist (NO TEXT OCR USED)

I1 n2 n3 DC 1m AC 1m
* SAME_NODE_SKIPPED I-DC both_on=0
V1 0 n3 DC 15
* SAME_NODE_SKIPPED V-DC both_on=0
L1 n1 n2 1m
C1 n3 0 1u
L2 n1 n4 1m
L3 n1 0 1m
I2 n1 n2 DC 1m AC 1m
C2 0 n5 1u
C3 n4 0 1u
C4 n2 0 1u
L4 n1 n3 1m

.op
.end
