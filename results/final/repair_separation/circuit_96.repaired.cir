* REPAIRED DECK -- interventions applied, listed below.
* The literal reconstruction is in the .literal.cir beside this file.
* interventions: 3
*   [gauge] ground_selection: used the GND symbol's net as reference (0)
*   [assumption/behaviour-changing] placeholder_values: assigned per-class placeholder values (no OCR)
*   [assumption/behaviour-changing] no_dc_path_to_ground: added shunt R 1e+09 from n15 to 0
* Auto-generated SPICE netlist (NO TEXT OCR USED)

Q1 n14 n9 n4 QPNPdefault
Q2 n12 n8 n6 QPNPdefault
D1 n5 n2 Ddefault
D2 n9 n5 Ddefault
Q3 n13 n10 n7 QPNPdefault
Q4 n9 n13 0 QNPNdefault
Q5 n4 n14 0 QNPNdefault
R1 n1 n3 1k
R2 n7 n4 1k
V1 n3 0 DC 15
Q6 0 n11 n8 QPNPdefault
R3 n6 n7 1k
R4 n3 n6 1k
Q7 n1 n2 n4 QNPNdefault
V2 n1 0 DC 15
V3 n4 0 DC 15
Q8 n12 n15 0 QNPNdefault
V4 n7 0 DC 15
Q9 n13 n15 0 QNPNdefault
R5 n10 0 1k
R6 n11 0 1k
.model Ddefault D
.model QNPNdefault NPN
.model QPNPdefault PNP

.op
.end
