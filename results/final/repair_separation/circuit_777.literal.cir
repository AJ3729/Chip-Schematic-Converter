* Auto-generated SPICE netlist (NO TEXT OCR USED)

V1 n3 n2 DC 15
V2 n2 n3 DC 15
L1 n3 0 1m
R1 n2 n1 1k
C1 n1 0 1u

.op
.end
