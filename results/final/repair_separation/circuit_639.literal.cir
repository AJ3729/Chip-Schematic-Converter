* Auto-generated SPICE netlist (NO TEXT OCR USED)

I1 0 n2 DC 1m AC 1m
* SAME_NODE_SKIPPED V-AC both_on=0
* SAME_NODE_SKIPPED V-DC both_on=0
L1 0 n2 1m
* SAME_NODE_SKIPPED Inductor both_on=0
* SAME_NODE_SKIPPED Capacitor both_on=0
* SAME_NODE_SKIPPED Capacitor both_on=0
C1 n2 0 1u
* SAME_NODE_SKIPPED Inductor both_on=0
* SAME_NODE_SKIPPED Inductor both_on=0
V1 n2 0 DC 15 AC 1
* SAME_NODE_SKIPPED Capacitor both_on=0
I2 0 n1 DC 1m
I3 0 n1 DC 1m

.op
.end
