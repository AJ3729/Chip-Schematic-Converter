* REPAIRED DECK -- interventions applied, listed below.
* The literal reconstruction is in the .literal.cir beside this file.
* interventions: 5
*   [gauge] unset_current_direction: kept drawn current-source reference direction
*   [gauge] ground_selection: used the GND symbol's net as reference (0)
*   [assumption/behaviour-changing] placeholder_values: assigned per-class placeholder values (no OCR)
*   [assumption/behaviour-changing] no_dc_path_to_ground: added shunt R 1e+09 from n15 to 0
*   [assumption] ideal_inductor_dc: none applied (DC short is well-posed); .nodeset available if singular
* Auto-generated SPICE netlist (NO TEXT OCR USED)

E1 n2 0 n5 n1 100k
E2 n14 0 n16 n13 100k
E3 n10 0 0 n9 100k
E4 n4 0 n7 n3 100k
E5 n7 0 n12 n11 100k
R1 n10 n8 1k
R2 n14 n8 1k
I1 n15 n11 DC 1m
R3 n2 n3 1k
L1 n13 n14 1m
R4 n4 n8 1k
V1 n6 n1 DC 15
L2 n11 n7 1m
C1 n9 n10 1u
R5 n7 n9 1k
C2 n7 n13 1u
L3 n3 n4 1m
C3 n1 n2 1u

.op
.end
