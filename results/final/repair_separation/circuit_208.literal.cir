* Auto-generated SPICE netlist (NO TEXT OCR USED)

V1 n1 0 DC 15 AC 1
D1 n6 n5 Ddefault
D2 n4 n8 Zdefault
D3 n8 0 Ddefault
D4 n3 0 Zdefault
D5 n6 n4 Ddefault
D6 n4 n3 Ddefault
D7 n2 n4 Zdefault
I1 n7 0 DC 1m
D8 n5 n2 Ddefault
L1 n1 n3 1m
C1 n3 n2 1u
L2 n4 n5 1m
C2 0 n4 1u
C3 n7 n8 1u
L3 n8 n6 1m
R1 n5 n9 1k
.model Ddefault D
.model Zdefault D(bv=5.1)

.op
.end
