* Auto-generated SPICE netlist (NO TEXT OCR USED)

V1 n2 n1 DC 15 AC 1
I1 n1 0 DC 1m AC 1m
* SAME_NODE_SKIPPED V-DC both_on=0
* SAME_NODE_SKIPPED V-DC both_on=0
* SAME_NODE_SKIPPED I-DC both_on=0
C1 n1 0 1u
C2 n5 0 1u
C3 n4 0 1u
L1 n2 n4 1m
L2 n2 n5 1m
L3 n2 n1 1m
L4 n2 n3 1m
C4 n3 0 1u

.op
.end
