* Auto-generated SPICE netlist (NO TEXT OCR USED)

I1 n2 0 DC 1m
L1 n3 n1 1m
L2 n5 n2 1m
C1 n3 n5 1u
V1 n4 0 DC 15
R1 n1 n2 1k
R2 n4 n3 1k
R3 n2 0 1k

.op
.end
