* REPAIRED DECK -- interventions applied, listed below.
* The literal reconstruction is in the .literal.cir beside this file.
* interventions: 5
*   [gauge] unset_current_direction: kept drawn current-source reference direction
*   [gauge] ground_selection: used the GND symbol's net as reference (0)
*   [assumption/behaviour-changing] placeholder_values: assigned per-class placeholder values (no OCR)
*   [assumption/behaviour-changing] no_dc_path_to_ground: added shunt R 1e+09 from n8 to 0
*   [assumption] ideal_inductor_dc: none applied (DC short is well-posed); .nodeset available if singular
* Auto-generated SPICE netlist (NO TEXT OCR USED)

V1 n3 n5 DC 15 AC 1
D1 n7 n4 Ddefault
D2 n4 n9 Zdefault
D3 n6 n1 Ddefault
D4 n2 n5 Zdefault
D5 n9 n5 Ddefault
D6 n4 n2 Ddefault
D7 n7 n6 Ddefault
L1 n4 n6 1m
D8 n1 n4 Zdefault
C1 n5 n4 1u
L2 n3 n2 1m
I1 n5 n8 DC 1m
C2 n2 n1 1u
C3 n8 n9 1u
L3 n9 n7 1m
R1 n6 0 1k
.model Ddefault D
.model Zdefault D(bv=5.1)

.op
.end
