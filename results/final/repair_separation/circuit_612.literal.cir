* Auto-generated SPICE netlist (NO TEXT OCR USED)

V1 n3 0 DC 15 AC 1
R1 n3 n2 1k
C1 n2 0 1u
L1 n2 n1 1m
R2 n1 0 1k

.op
.end
