* REPAIRED DECK -- interventions applied, listed below.
* The literal reconstruction is in the .literal.cir beside this file.
* interventions: 5
*   [gauge] unset_current_direction: kept drawn current-source reference direction
*   [gauge] ground_selection: used the GND symbol's net as reference (0)
*   [assumption/behaviour-changing] placeholder_values: assigned per-class placeholder values (no OCR)
*   [assumption/behaviour-changing] no_dc_path_to_ground: added shunt R 1e+09 from n1 to 0
*   [assumption] ideal_inductor_dc: none applied (DC short is well-posed); .nodeset available if singular
* Auto-generated SPICE netlist (NO TEXT OCR USED)

E1 n2 0 n5 n1 100k
E2 n10 0 n9 n12 100k
E3 n14 0 n15 n16 100k
E4 n8 0 n11 n13 100k
E5 n4 0 n8 n3 100k
I1 0 n11 DC 1m
V1 n7 n1 DC 15
R1 n10 n6 1k
L1 n3 n4 1m
C1 n8 n15 1u
R2 n4 n6 1k
R3 n14 n6 1k
R4 n8 n9 1k
C2 n9 n10 1u
L2 n11 n8 1m
R5 n2 n3 1k
C3 n1 n2 1u
L3 n15 n14 1m

.op
.end
