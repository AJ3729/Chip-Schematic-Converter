* Auto-generated SPICE netlist (NO TEXT OCR USED)

R1 n2 0 1k
V1 0 n1 DC 15
I1 0 n2 DC 1m
C1 n3 n2 1u
R2 n1 n3 1k
L1 n2 0 1m

.op
.end
