* Auto-generated SPICE netlist (NO TEXT OCR USED)

M1 n1 n4 n3 n3 PMOSdefault
V1 n2 n7 DC 15 AC 1
I1 n9 n10 DC 1m AC 1m
V2 n4 n7 DC 15 AC 1
M2 n6 n8 n7 n7 PMOSdefault
M3 n5 n3 n6 n6 PMOSdefault
I2 n8 n7 DC 1m AC 1m
M4 n1 n2 n3 n3 NMOSdefault
M5 n2 n4 n7 n7 NMOSdefault
D1 n1 n4 Zdefault
V3 n1 0 DC 15
R1 n4 n6 1k
.model NMOSdefault NMOS
.model PMOSdefault PMOS
.model Zdefault D(bv=5.1)

.op
.end
