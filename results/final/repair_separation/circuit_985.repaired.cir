* REPAIRED DECK -- interventions applied, listed below.
* The literal reconstruction is in the .literal.cir beside this file.
* interventions: 5
*   [gauge] unset_current_direction: kept drawn current-source reference direction
*   [gauge] ground_selection: used the GND symbol's net as reference (0)
*   [assumption/behaviour-changing] placeholder_values: assigned per-class placeholder values (no OCR)
*   [assumption/behaviour-changing] no_dc_path_to_ground: added shunt R 1e+09 from n5 to 0
*   [assumption/behaviour-changing] no_dc_path_to_ground: added shunt R 1e+09 from n8 to 0
* Auto-generated SPICE netlist (NO TEXT OCR USED)

I1 n5 n9 DC 1m AC 1m
I2 n8 n9 DC 1m AC 1m
M1 n3 n5 n6 n6 PMOSdefault
V1 n2 n9 DC 15 AC 1
M2 n1 n2 n3 n3 NMOSdefault
V2 n4 n9 DC 15 AC 1
D1 n1 n4 Zdefault
M3 n1 n4 n3 n3 PMOSdefault
M4 n6 n8 n9 n9 PMOSdefault
M5 n3 n4 n7 n7 NMOSdefault
V3 0 n1 DC 15
R1 n7 n6 1k
M6 n7 n2 n9 n9 NMOSdefault
M7 n7 n2 n9 n9 NMOSdefault
.model NMOSdefault NMOS
.model PMOSdefault PMOS
.model Zdefault D(bv=5.1)

.op
.end
