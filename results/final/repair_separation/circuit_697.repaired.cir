* REPAIRED DECK -- interventions applied, listed below.
* The literal reconstruction is in the .literal.cir beside this file.
* interventions: 4
*   [gauge] unset_current_direction: kept drawn current-source reference direction
*   [gauge] ground_selection: used the GND symbol's net as reference (0)
*   [assumption/behaviour-changing] placeholder_values: assigned per-class placeholder values (no OCR)
*   [assumption] ideal_inductor_dc: none applied (DC short is well-posed); .nodeset available if singular
* Auto-generated SPICE netlist (NO TEXT OCR USED)

V1 n4 n3 DC 15 AC 1
I1 n6 n5 DC 1m AC 1m
C1 n1 n3 1u
L1 n2 n1 1m
L2 n3 0 1m
R1 n2 n4 1k
R2 n3 n5 1k
R3 n4 n6 1k
R4 n1 0 1k

.op
.end
