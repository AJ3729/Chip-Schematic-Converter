* REPAIRED DECK -- interventions applied, listed below.
* The literal reconstruction is in the .literal.cir beside this file.
* interventions: 5
*   [gauge] unset_current_direction: kept drawn current-source reference direction
*   [gauge] ground_selection: used the GND symbol's net as reference (0)
*   [assumption/behaviour-changing] placeholder_values: assigned per-class placeholder values (no OCR)
*   [assumption/behaviour-changing] no_dc_path_to_ground: added shunt R 1e+09 from n1 to 0
*   [assumption] ideal_inductor_dc: none applied (DC short is well-posed); .nodeset available if singular
* Auto-generated SPICE netlist (NO TEXT OCR USED)

V1 n2 n1 DC 15 AC 1
I1 n1 0 DC 1m AC 1m
* SAME_NODE_SKIPPED V-DC both_on=0
* SAME_NODE_SKIPPED V-DC both_on=0
* SAME_NODE_SKIPPED I-DC both_on=0
C1 n1 0 1u
C2 n5 0 1u
C3 n4 0 1u
L1 n2 n4 1m
L2 n2 n5 1m
L3 n2 n1 1m
L4 n2 n3 1m
C4 n3 0 1u

.op
.end
