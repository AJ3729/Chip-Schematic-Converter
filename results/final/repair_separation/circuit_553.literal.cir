* Auto-generated SPICE netlist (NO TEXT OCR USED)

I1 n1 n2 DC 1m AC 1m
V1 0 n1 DC 15 AC 1
V2 n2 0 DC 15
* SAME_NODE_SKIPPED V-DC both_on=0
C1 n2 0 1u
C2 n1 0 1u
L1 0 n4 1m
C3 n4 0 1u
C4 n3 0 1u
L2 0 n2 1m
L3 0 n3 1m
L4 0 n1 1m
* SAME_NODE_SKIPPED I-DC both_on=0

.op
.end
