* Auto-generated SPICE netlist (NO TEXT OCR USED)

V1 n11 n16 DC 15 AC 1
D1 n1 n2 Zdefault
M1 n3 n11 n13 n13 PMOSdefault
M2 n1 n5 n1 n1 NMOSdefault
E1 n6 0 n7 n4 100k
M3 n7 n8 n9 n9 PMOSdefault
M4 n9 n14 n13 n13 PMOSdefault
M5 n5 n8 n10 n10 NMOSdefault
V2 n12 n8 DC 15
M6 n10 n15 0 0 NMOSdefault
M7 n1 n4 n1 n1 NMOSdefault
M8 n1 n2 n3 n3 NMOSdefault
L1 n6 n3 1m
L2 n15 n14 1m
V3 n1 0 DC 15
.model NMOSdefault NMOS
.model PMOSdefault PMOS
.model Zdefault D(bv=5.1)

.op
.end
