* REPAIRED DECK -- interventions applied, listed below.
* The literal reconstruction is in the .literal.cir beside this file.
* interventions: 6
*   [gauge] unset_current_direction: kept drawn current-source reference direction
*   [gauge] ground_selection: used the GND symbol's net as reference (0)
*   [assumption/behaviour-changing] placeholder_values: assigned per-class placeholder values (no OCR)
*   [assumption/behaviour-changing] no_dc_path_to_ground: added shunt R 1e+09 from n2 to 0
*   [assumption/behaviour-changing] no_dc_path_to_ground: added shunt R 1e+09 from n6 to 0
*   [assumption] ideal_inductor_dc: none applied (DC short is well-posed); .nodeset available if singular
* Auto-generated SPICE netlist (NO TEXT OCR USED)

I1 n3 n4 DC 1m AC 1m
I2 n6 0 DC 1m
V1 n1 n3 DC 15 AC 1
V2 0 n4 DC 15
* SAME_NODE_SKIPPED V-DC both_on=0
C1 n7 0 1u
L1 n1 n5 1m
C2 n4 0 1u
C3 n5 0 1u
L2 n1 n7 1m
C4 n3 0 1u
L3 n1 n4 1m
L4 n2 n3 1m

.op
.end
