* Auto-generated SPICE netlist (NO TEXT OCR USED)

I1 n1 0 DC 1m
C1 n4 0 1u
V1 0 n1 DC 15
R1 n1 0 1k
R2 n3 0 1k
R3 n2 n4 1k
L1 n1 n2 1m
L2 n1 n3 1m

.op
.end
