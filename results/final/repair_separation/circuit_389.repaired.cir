* REPAIRED DECK -- interventions applied, listed below.
* The literal reconstruction is in the .literal.cir beside this file.
* interventions: 5
*   [gauge] unset_current_direction: kept drawn current-source reference direction
*   [gauge] ground_selection: used the GND symbol's net as reference (0)
*   [assumption/behaviour-changing] placeholder_values: assigned per-class placeholder values (no OCR)
*   [assumption/behaviour-changing] no_dc_path_to_ground: added shunt R 1e+09 from n2 to 0
*   [assumption] ideal_inductor_dc: none applied (DC short is well-posed); .nodeset available if singular
* Auto-generated SPICE netlist (NO TEXT OCR USED)

V1 n4 n3 DC 15 AC 1
C1 n6 0 1u
L1 n5 n4 1m
C2 n8 n6 1u
I1 n2 n1 DC 1m
R1 n2 n6 1k
R2 n4 n8 1k
R3 n5 n7 1k
L2 n1 0 1m
L3 n3 n2 1m
L4 n3 n2 1m

.op
.end
