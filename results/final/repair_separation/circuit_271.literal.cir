* Auto-generated SPICE netlist (NO TEXT OCR USED)

V1 0 n2 DC 15
L1 n3 n1 1m
R1 n1 0 1k
R2 n2 n3 1k
C1 n1 0 1u

.op
.end
