* REPAIRED DECK -- interventions applied, listed below.
* The literal reconstruction is in the .literal.cir beside this file.
* interventions: 5
*   [gauge] unset_current_direction: kept drawn current-source reference direction
*   [gauge] ground_selection: used the GND symbol's net as reference (0)
*   [assumption/behaviour-changing] placeholder_values: assigned per-class placeholder values (no OCR)
*   [assumption/behaviour-changing] no_dc_path_to_ground: added shunt R 1e+09 from n9 to 0
*   [assumption] ideal_inductor_dc: none applied (DC short is well-posed); .nodeset available if singular
* Auto-generated SPICE netlist (NO TEXT OCR USED)

V1 n3 n6 DC 15 AC 1
D1 n4 n7 Zdefault
D2 n2 n6 Zdefault
D3 n4 n2 Ddefault
I1 n6 n9 DC 1m
D4 n1 n4 Zdefault
D5 n5 n1 Ddefault
D6 n4 n8 Ddefault
D7 n7 n6 Ddefault
C1 n2 n1 1u
D8 n8 n5 Ddefault
C2 n6 n4 1u
L1 n3 n2 1m
L2 n7 n8 1m
C3 n9 n7 1u
L3 n4 n5 1m
R1 n5 0 1k
.model Ddefault D
.model Zdefault D(bv=5.1)

.op
.end
