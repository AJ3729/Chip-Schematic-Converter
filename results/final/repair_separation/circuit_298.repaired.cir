* REPAIRED DECK -- interventions applied, listed below.
* The literal reconstruction is in the .literal.cir beside this file.
* interventions: 5
*   [gauge] unset_current_direction: kept drawn current-source reference direction
*   [gauge] ground_selection: used the GND symbol's net as reference (0)
*   [assumption/behaviour-changing] placeholder_values: assigned per-class placeholder values (no OCR)
*   [assumption/behaviour-changing] no_dc_path_to_ground: added shunt R 1e+09 from n1 to 0
*   [assumption] ideal_inductor_dc: none applied (DC short is well-posed); .nodeset available if singular
* Auto-generated SPICE netlist (NO TEXT OCR USED)

E1 n10 0 n13 n11 100k
E2 n15 0 n17 n16 100k
I1 0 n12 DC 1m
E3 n2 0 n6 n3 100k
V1 n9 n3 DC 15
R1 n10 n8 1k
E4 n5 0 n7 n4 100k
L1 n4 n5 1m
C1 n1 n2 1u
L2 n12 n7 1m
R2 n5 n8 1k
R3 n2 n4 1k
R4 n15 n8 1k
C2 n7 n16 1u
C3 n11 n10 1u
L3 n16 n15 1m
R5 n7 n11 1k
E5 n7 0 n14 n12 100k

.op
.end
