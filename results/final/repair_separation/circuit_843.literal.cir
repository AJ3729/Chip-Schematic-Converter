* Auto-generated SPICE netlist (NO TEXT OCR USED)

V1 n4 0 DC 15 AC 1
L1 n2 n1 1m
C1 n4 n1 1u
I1 0 n1 DC 1m
I2 n2 0 DC 1m
R1 n2 n3 1k

.op
.end
