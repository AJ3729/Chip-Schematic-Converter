* Auto-generated SPICE netlist (NO TEXT OCR USED)

I1 n2 0 DC 1m
V1 0 n3 DC 15
C1 n2 0 1u
C2 n1 n4 1u
L1 n4 0 1m
R1 n2 n1 1k
R2 n1 n3 1k

.op
.end
