* Auto-generated SPICE netlist (NO TEXT OCR USED)

V1 n1 n6 DC 15 AC 1
D1 n4 n3 Ddefault
D2 n8 n4 Ddefault
D3 n8 n5 Ddefault
D4 n2 n4 Zdefault
D5 n5 n2 Ddefault
D6 n7 n6 Ddefault
I1 n9 n6 DC 1m
D7 n4 n7 Zdefault
D8 n3 n6 Zdefault
L1 n4 n5 1m
C1 n3 n2 1u
C2 n9 n7 1u
L2 n1 n3 1m
C3 n6 n4 1u
R1 n5 0 1k
L3 n7 n8 1m
.model Ddefault D
.model Zdefault D(bv=5.1)

.op
.end
