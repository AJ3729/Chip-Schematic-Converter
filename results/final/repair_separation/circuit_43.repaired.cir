* REPAIRED DECK -- interventions applied, listed below.
* The literal reconstruction is in the .literal.cir beside this file.
* interventions: 3
*   [gauge] ground_selection: used the GND symbol's net as reference (0)
*   [assumption/behaviour-changing] placeholder_values: assigned per-class placeholder values (no OCR)
*   [assumption/behaviour-changing] no_dc_path_to_ground: added shunt R 1e+09 from n15 to 0
* Auto-generated SPICE netlist (NO TEXT OCR USED)

Q1 n14 n10 n4 QPNPdefault
D1 n10 n6 Ddefault
Q2 n10 n12 0 QNPNdefault
Q3 n12 n9 n7 QPNPdefault
D2 n6 n3 Ddefault
Q4 n12 n15 0 QNPNdefault
Q5 n11 n8 n5 QPNPdefault
Q6 n1 n3 n4 QNPNdefault
R1 n5 n7 1k
R2 n7 n4 1k
V1 n1 0 DC 15
Q7 n11 n15 0 QNPNdefault
V2 n7 0 DC 15
Q8 n4 n14 0 QNPNdefault
V3 n2 0 DC 15
V4 n13 0 DC 15
R3 n1 n2 1k
V5 n4 0 DC 15
Q9 0 n13 n8 QPNPdefault
R4 n9 0 1k
R5 n2 n5 1k
R6 n13 0 1k
.model Ddefault D
.model QNPNdefault NPN
.model QPNPdefault PNP

.op
.end
