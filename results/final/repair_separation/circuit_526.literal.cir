* Auto-generated SPICE netlist (NO TEXT OCR USED)

I1 n3 0 DC 1m
V1 n4 n5 DC 15
R1 n4 n3 1k
L1 n2 n5 1m
C1 0 n2 1u
R2 0 n1 1k
R3 n1 n4 1k
R4 0 n1 1k

.op
.end
