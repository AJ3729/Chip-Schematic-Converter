* Auto-generated SPICE netlist (NO TEXT OCR USED)

C1 n1 0 1u
I1 n1 0 DC 1m
L1 n2 0 1m
R1 n1 n2 1k

.op
.end
