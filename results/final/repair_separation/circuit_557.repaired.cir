* REPAIRED DECK -- interventions applied, listed below.
* The literal reconstruction is in the .literal.cir beside this file.
* interventions: 4
*   [gauge] unset_current_direction: kept drawn current-source reference direction
*   [gauge] ground_selection: used the GND symbol's net as reference (0)
*   [assumption/behaviour-changing] placeholder_values: assigned per-class placeholder values (no OCR)
*   [assumption] ideal_inductor_dc: none applied (DC short is well-posed); .nodeset available if singular
* Auto-generated SPICE netlist (NO TEXT OCR USED)

I1 n2 0 DC 1m AC 1m
V1 0 n2 DC 15 AC 1
* SAME_NODE_SKIPPED V-DC both_on=0
C1 n2 0 1u
L1 0 n2 1m
L2 0 n3 1m
* SAME_NODE_SKIPPED Capacitor both_on=0
* SAME_NODE_SKIPPED Inductor both_on=0
C2 n3 0 1u
* SAME_NODE_SKIPPED Capacitor both_on=0
* SAME_NODE_SKIPPED I-DC both_on=0
* SAME_NODE_SKIPPED I-DC both_on=0
V2 n1 0 DC 15
V3 n1 0 DC 15

.op
.end
