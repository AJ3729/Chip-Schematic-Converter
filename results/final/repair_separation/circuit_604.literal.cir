* Auto-generated SPICE netlist (NO TEXT OCR USED)

D1 n11 n6 Ddefault
Q1 n11 n13 0 QNPNdefault
Q2 0 n9 n8 QPNPdefault
R1 n8 n7 1k
D2 n6 n2 Ddefault
R2 n7 n5 1k
Q3 n14 n11 n5 QPNPdefault
V1 n9 0 DC 15
R3 n3 n8 1k
V2 n7 0 DC 15
Q4 n5 n14 0 QNPNdefault
Q5 n1 n2 n5 QNPNdefault
Q6 0 n12 n9 QPNPdefault
R4 n12 0 1k
V3 n1 0 DC 15
V4 n4 0 DC 15
R5 n10 0 1k
Q7 n13 n10 n7 QPNPdefault
R6 n1 n3 1k
Q8 n13 0 0 QNPNdefault
V5 n5 0 DC 15
.model Ddefault D
.model QNPNdefault NPN
.model QPNPdefault PNP

.op
.end
