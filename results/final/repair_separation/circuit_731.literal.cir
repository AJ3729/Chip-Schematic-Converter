* Auto-generated SPICE netlist (NO TEXT OCR USED)

V1 0 n2 DC 15
C1 n1 n3 1u
I1 n1 0 DC 1m
R1 n3 n2 1k
L1 0 n3 1m

.op
.end
