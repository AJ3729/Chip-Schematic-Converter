* REPAIRED DECK -- interventions applied, listed below.
* The literal reconstruction is in the .literal.cir beside this file.
* interventions: 3
*   [gauge] unset_current_direction: kept drawn current-source reference direction
*   [assumption/behaviour-changing] placeholder_values: assigned per-class placeholder values (no OCR)
*   [assumption] ideal_inductor_dc: none applied (DC short is well-posed); .nodeset available if singular
* Auto-generated SPICE netlist (NO TEXT OCR USED)

I1 0 n6 DC 1m
I2 n7 n3 DC 1m
V1 n7 n6 DC 15
C1 n4 n5 1u
C2 n1 n2 1u
R1 n3 n7 1k
R2 n7 n6 1k
R3 0 n6 1k
L1 n3 n1 1m
L2 n2 0 1m
L3 n5 0 1m
L4 n3 n4 1m

.op
.end
