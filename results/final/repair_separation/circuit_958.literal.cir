* Auto-generated SPICE netlist (NO TEXT OCR USED)

I1 n3 0 DC 1m AC 1m
V1 n1 n2 DC 15 AC 1
R1 n2 n3 1k
C1 n2 0 1u
L1 n1 0 1m
L2 n1 0 1m

.op
.end
