* Auto-generated SPICE netlist (NO TEXT OCR USED)

V1 0 n2 DC 15
L1 n1 0 1m
R1 n2 n1 1k
C1 n1 0 1u
R2 n1 0 1k

.op
.end
