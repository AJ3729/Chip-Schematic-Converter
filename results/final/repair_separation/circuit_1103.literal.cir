* Auto-generated SPICE netlist (NO TEXT OCR USED)

V1 n3 0 DC 15 AC 1
C1 n2 n1 1u
R1 n3 n2 1k
L1 n1 0 1m

.op
.end
