* Auto-generated SPICE netlist (NO TEXT OCR USED)

V1 n1 n5 DC 15 AC 1
D1 n4 n6 Zdefault
D2 n7 n4 Ddefault
D3 n7 n3 Ddefault
D4 n4 n1 Ddefault
D5 n3 n2 Ddefault
D6 n1 n5 Zdefault
C1 n5 n4 1u
I1 n8 n5 DC 1m
D7 n5 n6 Ddefault
L1 n4 n3 1m
C2 n8 n6 1u
C3 n1 n2 1u
L2 n6 n7 1m
D8 n2 n4 Zdefault
R1 n3 0 1k
.model Ddefault D
.model Zdefault D(bv=5.1)

.op
.end
