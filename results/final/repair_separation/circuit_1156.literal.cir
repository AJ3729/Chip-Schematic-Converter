* Auto-generated SPICE netlist (NO TEXT OCR USED)

V1 n3 n6 DC 15 AC 1
D1 n5 n1 Ddefault
D2 n2 n6 Zdefault
D3 n4 n8 Zdefault
I1 n9 n6 DC 1m
D4 n1 n4 Zdefault
D5 n4 n2 Ddefault
D6 n7 n4 Ddefault
D7 n6 n8 Ddefault
D8 n7 n5 Ddefault
L1 n8 n7 1m
R1 n5 0 1k
C1 n6 n4 1u
L2 n3 n2 1m
C2 n2 n1 1u
C3 n9 n8 1u
L3 n4 n5 1m
.model Ddefault D
.model Zdefault D(bv=5.1)

.op
.end
