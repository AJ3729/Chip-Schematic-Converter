* Auto-generated SPICE netlist (NO TEXT OCR USED)

V1 n2 n1 DC 15 AC 1
I1 n4 0 DC 1m AC 1m
V2 n2 0 DC 15 AC 1
L1 n3 n4 1m
C1 n1 n3 1u
R1 n2 n3 1k

.op
.end
