* Auto-generated SPICE netlist (NO TEXT OCR USED)

V1 n4 0 DC 15 AC 1
R1 n2 0 1k
I1 n1 0 DC 1m AC 1m
C1 n3 n1 1u
R2 n4 n3 1k
L1 n1 n2 1m
R3 n3 0 1k

.op
.end
