* Auto-generated SPICE netlist (NO TEXT OCR USED)

V1 n2 0 DC 15
C1 n2 0 1u
L1 n2 0 1m
I1 0 n1 DC 1m
R1 n1 n2 1k
R2 n2 0 1k
R3 n1 0 1k

.op
.end
