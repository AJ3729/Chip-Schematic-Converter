* Auto-generated SPICE netlist (NO TEXT OCR USED)

V1 n1 0 DC 15 AC 1
R1 n1 n3 1k
C1 n3 0 1u
L1 n1 n2 1m
R2 n2 0 1k
R3 n1 0 1k

.op
.end
