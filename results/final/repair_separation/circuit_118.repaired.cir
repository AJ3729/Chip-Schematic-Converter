* REPAIRED DECK -- interventions applied, listed below.
* The literal reconstruction is in the .literal.cir beside this file.
* interventions: 3
*   [gauge] ground_selection: used the GND symbol's net as reference (0)
*   [assumption/behaviour-changing] placeholder_values: assigned per-class placeholder values (no OCR)
*   [assumption/behaviour-changing] no_dc_path_to_ground: added shunt R 1e+09 from n15 to 0
* Auto-generated SPICE netlist (NO TEXT OCR USED)

D1 n5 n2 Ddefault
Q1 n13 n10 n6 QPNPdefault
Q2 n14 n8 n3 QPNPdefault
Q3 n3 n14 0 QNPNdefault
Q4 n11 n9 n7 QPNPdefault
Q5 n1 n2 n3 QNPNdefault
D2 n8 n5 Ddefault
Q6 n11 n15 0 QNPNdefault
Q7 n9 n12 0 QPNPdefault
R1 n7 n6 1k
R2 n6 n3 1k
Q8 n13 n15 0 QNPNdefault
V1 n6 0 DC 15
R3 n10 0 1k
R4 n1 n4 1k
V2 n12 0 DC 15
V3 n1 0 DC 15
Q9 n8 n13 0 QNPNdefault
R5 n4 n7 1k
V4 n4 0 DC 15
V5 n3 0 DC 15
R6 n12 0 1k
.model Ddefault D
.model QNPNdefault NPN
.model QPNPdefault PNP

.op
.end
