* REPAIRED DECK -- interventions applied, listed below.
* The literal reconstruction is in the .literal.cir beside this file.
* interventions: 3
*   [gauge] ground_selection: used the GND symbol's net as reference (0)
*   [assumption/behaviour-changing] placeholder_values: assigned per-class placeholder values (no OCR)
*   [assumption] ideal_inductor_dc: none applied (DC short is well-posed); .nodeset available if singular
* Auto-generated SPICE netlist (NO TEXT OCR USED)

V1 n3 0 DC 15
V2 0 n5 DC 15
V3 0 n4 DC 15
R1 n4 n2 1k
L1 n1 n3 1m
R2 n2 n1 1k
C1 n2 n5 1u
R3 n1 0 1k

.op
.end
