* REPAIRED DECK -- interventions applied, listed below.
* The literal reconstruction is in the .literal.cir beside this file.
* interventions: 4
*   [gauge] unset_current_direction: kept drawn current-source reference direction
*   [gauge] ground_selection: used the GND symbol's net as reference (0)
*   [assumption/behaviour-changing] placeholder_values: assigned per-class placeholder values (no OCR)
*   [assumption] ideal_inductor_dc: none applied (DC short is well-posed); .nodeset available if singular
* Auto-generated SPICE netlist (NO TEXT OCR USED)

I1 n4 n3 DC 1m
V1 n1 0 DC 15
C1 n3 0 1u
C2 n1 n3 1u
L1 n2 n1 1m
L2 0 n4 1m
R1 n2 n3 1k
R2 n3 n4 1k

.op
.end
