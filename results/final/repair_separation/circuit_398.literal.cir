* Auto-generated SPICE netlist (NO TEXT OCR USED)

E1 n3 0 n7 n4 100k
E2 n2 0 n5 n1 100k
E3 n7 0 n12 n10 100k
E4 n14 0 n13 n16 100k
E5 n9 0 n8 n11 100k
V1 0 n1 DC 15
I1 n10 n15 DC 1m
R1 n3 n6 1k
R2 n14 n6 1k
R3 n2 n4 1k
C1 n7 n13 1u
L1 n4 n3 1m
C2 n1 n2 1u
R4 n9 n6 1k
C3 n8 n9 1u
L2 n10 n7 1m
R5 n7 n8 1k
L3 n13 n14 1m

.op
.end
