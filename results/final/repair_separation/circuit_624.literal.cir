* Auto-generated SPICE netlist (NO TEXT OCR USED)

V1 n2 0 DC 15 AC 1
V2 n1 0 DC 15 AC 1
C1 n2 0 1u
R1 n1 n2 1k
R2 n2 0 1k
L1 n2 0 1m

.op
.end
