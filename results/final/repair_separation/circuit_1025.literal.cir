* Auto-generated SPICE netlist (NO TEXT OCR USED)

V1 0 n1 DC 15
I1 0 n3 DC 1m
C1 n3 0 1u
L1 n3 0 1m
R1 n3 n2 1k
R2 n2 n1 1k
R3 n2 0 1k

.op
.end
