* Auto-generated SPICE netlist (NO TEXT OCR USED)

E1 n2 0 n5 n1 100k
E2 n10 0 n9 n12 100k
E3 n14 0 n15 n16 100k
E4 n8 0 n11 n13 100k
E5 n4 0 n8 n3 100k
I1 0 n11 DC 1m
V1 n7 n1 DC 15
R1 n10 n6 1k
L1 n3 n4 1m
C1 n8 n15 1u
R2 n4 n6 1k
R3 n14 n6 1k
R4 n8 n9 1k
C2 n9 n10 1u
L2 n11 n8 1m
R5 n2 n3 1k
C3 n1 n2 1u
L3 n15 n14 1m

.op
.end
