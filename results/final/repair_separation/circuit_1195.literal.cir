* Auto-generated SPICE netlist (NO TEXT OCR USED)

V1 n4 n5 DC 15
R1 n3 n1 1k
L1 n2 n3 1m
C1 n1 n4 1u
I1 0 n2 DC 1m
R2 n2 0 1k
R3 0 n5 1k

.op
.end
