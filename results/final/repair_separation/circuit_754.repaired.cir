* REPAIRED DECK -- interventions applied, listed below.
* The literal reconstruction is in the .literal.cir beside this file.
* interventions: 5
*   [gauge] ground_selection: used the GND symbol's net as reference (0)
*   [assumption/behaviour-changing] placeholder_values: assigned per-class placeholder values (no OCR)
*   [assumption/behaviour-changing] no_dc_path_to_ground: added shunt R 1e+09 from n11 to 0
*   [assumption/behaviour-changing] no_dc_path_to_ground: added shunt R 1e+09 from n14 to 0
*   [assumption] ideal_inductor_dc: none applied (DC short is well-posed); .nodeset available if singular
* Auto-generated SPICE netlist (NO TEXT OCR USED)

V1 n11 n13 DC 15 AC 1
E1 n6 0 n7 n5 100k
D1 n1 n2 Zdefault
M1 n8 n7 n10 n10 PMOSdefault
M2 n4 n11 n10 n10 PMOSdefault
M3 n10 n15 0 0 PMOSdefault
M4 n1 n1 n3 n3 NMOSdefault
M5 n3 n8 n9 n9 NMOSdefault
V2 n12 n8 DC 15
M6 n1 n2 n4 n4 NMOSdefault
V3 n1 0 DC 15
L1 n6 n4 1m
M7 n9 n14 0 0 NMOSdefault
L2 n14 n15 1m
M8 n1 n1 n5 n5 NMOSdefault
M9 n1 n1 n5 n5 NMOSdefault
.model NMOSdefault NMOS
.model PMOSdefault PMOS
.model Zdefault D(bv=5.1)

.op
.end
