* Auto-generated SPICE netlist (NO TEXT OCR USED)

E1 n2 0 n1 n5 100k
E2 n10 0 0 n9 100k
E3 n7 0 n12 n11 100k
I1 n15 n11 DC 1m
E4 n14 0 n16 n13 100k
E5 n4 0 n7 n3 100k
L1 n13 n14 1m
V1 n8 n1 DC 15
R1 n2 n3 1k
R2 n10 n6 1k
L2 n3 n4 1m
L3 n11 n7 1m
R3 n14 n6 1k
R4 n4 n6 1k
C1 n9 n10 1u
R5 n7 n9 1k
C2 n7 n13 1u
C3 n1 n2 1u

.op
.end
