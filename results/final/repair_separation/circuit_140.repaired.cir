* REPAIRED DECK -- interventions applied, listed below.
* The literal reconstruction is in the .literal.cir beside this file.
* interventions: 3
*   [gauge] ground_selection: used the GND symbol's net as reference (0)
*   [assumption/behaviour-changing] placeholder_values: assigned per-class placeholder values (no OCR)
*   [assumption/behaviour-changing] no_dc_path_to_ground: added shunt R 1e+09 from n6 to 0
* Auto-generated SPICE netlist (NO TEXT OCR USED)

V1 n9 0 DC 15
Q1 n7 n6 0 QNPNdefault
R1 n9 n8 1k
R2 n1 n9 1k
R3 n11 0 1k
R4 n5 n8 1k
R5 n4 0 1k
R6 n1 n5 1k
Q2 n3 n4 n5 QPNPdefault
D1 n1 n2 Ddefault
Q3 n3 n6 0 QNPNdefault
Q4 n1 n1 0 QNPNdefault
V2 n11 0 DC 15
Q5 n7 n10 n8 QPNPdefault
D2 n2 n1 Ddefault
V3 n1 0 DC 15
V4 n5 0 DC 15
Q6 0 n11 n10 QPNPdefault
V5 n1 0 DC 15
Q7 n1 n3 0 QNPNdefault
.model Ddefault D
.model QNPNdefault NPN
.model QPNPdefault PNP

.op
.end
