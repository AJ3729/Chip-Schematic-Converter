* REPAIRED DECK -- interventions applied, listed below.
* The literal reconstruction is in the .literal.cir beside this file.
* interventions: 5
*   [gauge] unset_current_direction: kept drawn current-source reference direction
*   [gauge] ground_selection: used the GND symbol's net as reference (0)
*   [assumption/behaviour-changing] placeholder_values: assigned per-class placeholder values (no OCR)
*   [assumption/behaviour-changing] no_dc_path_to_ground: added shunt R 1e+09 from n13 to 0
*   [assumption] ideal_inductor_dc: none applied (DC short is well-posed); .nodeset available if singular
* Auto-generated SPICE netlist (NO TEXT OCR USED)

E1 n15 0 n16 n14 100k
E2 n7 0 n12 n11 100k
E3 n1 0 n6 n2 100k
E4 n3 0 n7 n4 100k
E5 n9 0 0 n10 100k
C1 n10 n9 1u
I1 n11 n13 DC 1m
R1 n15 n5 1k
C2 n2 n1 1u
V1 n2 n8 DC 15
L1 n11 n7 1m
R2 n3 n5 1k
L2 n14 n15 1m
R3 n1 n4 1k
R4 n7 n10 1k
L3 n4 n3 1m
R5 n9 n5 1k
C3 n7 n14 1u

.op
.end
