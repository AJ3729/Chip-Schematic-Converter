* REPAIRED DECK -- interventions applied, listed below.
* The literal reconstruction is in the .literal.cir beside this file.
* interventions: 4
*   [gauge] unset_current_direction: kept drawn current-source reference direction
*   [gauge] ground_selection: used the GND symbol's net as reference (0)
*   [assumption/behaviour-changing] placeholder_values: assigned per-class placeholder values (no OCR)
*   [assumption] ideal_inductor_dc: none applied (DC short is well-posed); .nodeset available if singular
* Auto-generated SPICE netlist (NO TEXT OCR USED)

* SAME_NODE_SKIPPED I-AC both_on=0
* SAME_NODE_SKIPPED V-AC both_on=0
* SAME_NODE_SKIPPED V-DC both_on=0
* SAME_NODE_SKIPPED V-DC both_on=0
* SAME_NODE_SKIPPED I-DC both_on=0
* SAME_NODE_SKIPPED Capacitor both_on=0
* SAME_NODE_SKIPPED Capacitor both_on=0
* SAME_NODE_SKIPPED Capacitor both_on=0
* SAME_NODE_SKIPPED Inductor both_on=0
* SAME_NODE_SKIPPED Inductor both_on=0
* SAME_NODE_SKIPPED Capacitor both_on=0
* SAME_NODE_SKIPPED Inductor both_on=0
* SAME_NODE_SKIPPED Inductor both_on=0
* WARNING: no valid components written

.op
.end
