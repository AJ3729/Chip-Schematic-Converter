* Auto-generated SPICE netlist (NO TEXT OCR USED)

I1 n3 0 DC 1m
C1 n4 0 1u
L1 0 n5 1m
R1 n4 n2 1k
V1 n5 n1 DC 15
R2 n2 n1 1k
R3 n3 n4 1k
R4 n2 0 1k

.op
.end
