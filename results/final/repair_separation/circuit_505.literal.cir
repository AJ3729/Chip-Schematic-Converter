* Auto-generated SPICE netlist (NO TEXT OCR USED)

I1 0 n2 DC 1m
V1 0 n1 DC 15
I2 n1 n2 DC 1m
C1 n2 0 1u
R1 n2 0 1k
R2 n1 0 1k
R3 n1 0 1k
L1 n3 0 1m

.op
.end
