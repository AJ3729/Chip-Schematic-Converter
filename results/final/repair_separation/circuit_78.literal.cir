* Auto-generated SPICE netlist (NO TEXT OCR USED)

I1 n3 0 DC 1m AC 1m
V1 n1 0 DC 15 AC 1
V2 n2 0 DC 15 AC 1
C1 n3 0 1u
R1 n1 n2 1k
L1 n2 n3 1m

.op
.end
