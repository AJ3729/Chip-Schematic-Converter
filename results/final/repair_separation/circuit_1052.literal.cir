* Auto-generated SPICE netlist (NO TEXT OCR USED)

I1 n3 0 DC 1m AC 1m
V1 n4 0 DC 15 AC 1
C1 n2 n1 1u
R1 n1 n4 1k
L1 n2 n1 1m
R2 n3 n2 1k

.op
.end
