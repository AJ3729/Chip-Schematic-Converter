* Auto-generated SPICE netlist (NO TEXT OCR USED)

E1 n10 0 n8 n12 100k
E2 n2 0 n1 0 100k
E3 n4 0 n3 n6 100k
E4 n15 0 n16 n14 100k
E5 n6 0 n11 n9 100k
I1 n9 n13 DC 1m
V1 n1 n7 DC 15
R1 n6 n8 1k
L1 n3 n4 1m
R2 n2 n3 1k
R3 n15 n5 1k
R4 n4 n5 1k
L2 n14 n15 1m
C1 n1 n2 1u
C2 n8 n10 1u
C3 n6 n14 1u
R5 n10 n5 1k
L3 n9 n6 1m

.op
.end
