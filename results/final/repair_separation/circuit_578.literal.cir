* Auto-generated SPICE netlist (NO TEXT OCR USED)

V1 n3 n5 DC 15 AC 1
D1 n8 n4 Ddefault
D2 n9 n5 Ddefault
D3 n8 n6 Ddefault
I1 n10 n5 DC 1m
D4 n2 n5 Zdefault
L1 n4 n6 1m
D5 n4 n9 Zdefault
D6 n6 n1 Ddefault
D7 n4 n2 Ddefault
R1 n6 0 1k
L2 n3 n2 1m
C1 n2 n1 1u
L3 n9 n8 1m
C2 n10 n9 1u
D8 n1 n7 Zdefault
C3 n5 n4 1u
.model Ddefault D
.model Zdefault D(bv=5.1)

.op
.end
