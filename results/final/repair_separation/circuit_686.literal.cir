* Auto-generated SPICE netlist (NO TEXT OCR USED)

I1 0 n2 DC 1m
V1 n1 n5 DC 15
L1 n4 n3 1m
C1 n5 0 1u
L2 n2 n4 1m
R1 n3 n1 1k
R2 n3 0 1k

.op
.end
