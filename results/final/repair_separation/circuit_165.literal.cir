* Auto-generated SPICE netlist (NO TEXT OCR USED)

V1 0 n3 DC 15
R1 n3 n2 1k
C1 n2 n1 1u
I1 0 n1 DC 1m
L1 n2 0 1m
R2 n1 0 1k

.op
.end
