* REPAIRED DECK -- interventions applied, listed below.
* The literal reconstruction is in the .literal.cir beside this file.
* interventions: 5
*   [gauge] unset_current_direction: kept drawn current-source reference direction
*   [gauge] ground_selection: used the GND symbol's net as reference (0)
*   [assumption/behaviour-changing] placeholder_values: assigned per-class placeholder values (no OCR)
*   [assumption/behaviour-changing] no_dc_path_to_ground: added shunt R 1e+09 from n13 to 0
*   [assumption] ideal_inductor_dc: none applied (DC short is well-posed); .nodeset available if singular
* Auto-generated SPICE netlist (NO TEXT OCR USED)

E1 n7 0 n12 n11 100k
E2 n15 0 n16 n14 100k
E3 n4 0 n7 n3 100k
E4 n10 0 0 n9 100k
E5 n1 0 n5 n2 100k
I1 n11 n13 DC 1m
V1 n2 n8 DC 15
R1 n10 n6 1k
R2 n4 n6 1k
R3 n1 n3 1k
R4 n7 n9 1k
R5 n15 n6 1k
C1 n2 n1 1u
L1 n14 n15 1m
L2 n3 n4 1m
C2 n9 n10 1u
C3 n7 n14 1u
L3 n11 n7 1m

.op
.end
