* REPAIRED DECK -- interventions applied, listed below.
* The literal reconstruction is in the .literal.cir beside this file.
* interventions: 3
*   [gauge] ground_selection: used the GND symbol's net as reference (0)
*   [assumption/behaviour-changing] placeholder_values: assigned per-class placeholder values (no OCR)
*   [assumption] ideal_inductor_dc: none applied (DC short is well-posed); .nodeset available if singular
* Auto-generated SPICE netlist (NO TEXT OCR USED)

E1 n10 0 n11 n15 100k
E2 n3 0 n2 n9 100k
E3 n13 0 n16 n12 100k
E4 n5 0 n8 n4 100k
E5 n17 0 0 n18 100k
E6 n1 0 n6 n1 100k
R1 n10 n9 1k
R2 n3 n12 1k
R3 n13 n7 1k
R4 n3 n4 1k
R5 n5 n7 1k
L1 n11 n10 1m
R6 n17 n7 1k
L2 n4 n5 1m
R7 n1 n2 1k
C1 n12 n13 1u
C2 n3 n18 1u
L3 n18 n17 1m
L4 n2 n3 1m
V1 n1 0 DC 15
R8 n9 n14 1k
V2 n11 0 DC 15

.op
.end
