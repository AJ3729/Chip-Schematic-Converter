* REPAIRED DECK -- interventions applied, listed below.
* The literal reconstruction is in the .literal.cir beside this file.
* interventions: 5
*   [gauge] unset_current_direction: kept drawn current-source reference direction
*   [gauge] ground_selection: used the GND symbol's net as reference (0)
*   [assumption/behaviour-changing] placeholder_values: assigned per-class placeholder values (no OCR)
*   [assumption/behaviour-changing] no_dc_path_to_ground: added shunt R 1e+09 from n9 to 0
*   [assumption] ideal_inductor_dc: none applied (DC short is well-posed); .nodeset available if singular
* Auto-generated SPICE netlist (NO TEXT OCR USED)

V1 n3 n5 DC 15 AC 1
D1 n7 n6 Ddefault
D2 n4 n8 Zdefault
D3 n1 n4 Ddefault
D4 n1 n5 Zdefault
D5 n5 n8 Ddefault
D6 n6 n2 Ddefault
D7 n2 n4 Zdefault
D8 n4 n7 Ddefault
I1 n9 n5 DC 1m
C1 n5 n4 1u
C2 n1 n2 1u
L1 n8 n7 1m
C3 n9 n8 1u
L2 n3 n1 1m
R1 n6 0 1k
L3 n4 n6 1m
.model Ddefault D
.model Zdefault D(bv=5.1)

.op
.end
