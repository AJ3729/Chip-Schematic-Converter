* Auto-generated SPICE netlist (NO TEXT OCR USED)

I1 n3 0 DC 1m AC 1m
V1 n1 0 DC 15 AC 1
C1 n2 n3 1u
L1 n3 n4 1m
R1 n3 0 1k
R2 n1 n2 1k
R3 n4 0 1k

.op
.end
