* REPAIRED DECK -- interventions applied, listed below.
* The literal reconstruction is in the .literal.cir beside this file.
* interventions: 3
*   [gauge] ground_selection: used the GND symbol's net as reference (0)
*   [assumption/behaviour-changing] placeholder_values: assigned per-class placeholder values (no OCR)
*   [assumption/behaviour-changing] no_dc_path_to_ground: added shunt R 1e+09 from n15 to 0
* Auto-generated SPICE netlist (NO TEXT OCR USED)

D1 n8 n5 Ddefault
D2 n5 n3 Ddefault
R1 n7 n4 1k
Q1 n13 n8 n4 QPNPdefault
Q2 n11 n9 n6 QPNPdefault
Q3 0 n12 n9 QPNPdefault
Q4 n14 n10 n7 QPNPdefault
V1 n7 0 DC 15
V2 n12 0 DC 15
R2 n6 n7 1k
Q5 n1 n3 n4 QNPNdefault
Q6 n4 n13 0 QNPNdefault
Q7 n14 n15 0 QNPNdefault
R3 n1 n2 1k
V3 n2 0 DC 15
R4 n12 0 1k
R5 n10 0 1k
R6 n2 n6 1k
V4 n1 0 DC 15
Q8 n11 n15 0 QNPNdefault
V5 n4 0 DC 15
Q9 n8 n14 0 QNPNdefault
.model Ddefault D
.model QNPNdefault NPN
.model QPNPdefault PNP

.op
.end
