* Auto-generated SPICE netlist (NO TEXT OCR USED)

E1 n2 0 n5 n1 100k
E2 n9 0 n10 0 100k
E3 n4 0 n7 n3 100k
E4 n7 0 n12 n11 100k
E5 n15 0 n17 n14 100k
I1 n11 n13 DC 1m
R1 n4 n6 1k
L1 n11 n7 1m
V1 n8 n1 DC 15
R2 n9 n6 1k
R3 n7 n10 1k
R4 n15 n6 1k
R5 n2 n3 1k
C1 n1 n2 1u
L2 n3 n4 1m
C2 n7 n14 1u
L3 n14 n16 1m
C3 n10 n9 1u

.op
.end
