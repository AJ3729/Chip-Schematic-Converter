* Auto-generated SPICE netlist (NO TEXT OCR USED)

V1 n3 n4 DC 15 AC 1
D1 n1 n5 Zdefault
D2 n7 n5 Ddefault
D3 n2 n4 Zdefault
D4 n4 n8 Ddefault
D5 n5 n2 Ddefault
D6 n5 n8 Zdefault
D7 n6 n1 Ddefault
I1 n9 n4 DC 1m
D8 n7 n6 Ddefault
L1 n3 n2 1m
C1 n9 n8 1u
L2 n5 n6 1m
C2 n2 n1 1u
R1 n6 0 1k
L3 n8 n7 1m
C3 n4 n5 1u
.model Ddefault D
.model Zdefault D(bv=5.1)

.op
.end
