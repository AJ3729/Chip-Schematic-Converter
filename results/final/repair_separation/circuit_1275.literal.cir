* Auto-generated SPICE netlist (NO TEXT OCR USED)

V1 0 n3 DC 15
C1 n3 n1 1u
R1 n1 n2 1k
C2 n3 n1 1u
R2 n1 n2 1k
L1 n2 0 1m

.op
.end
