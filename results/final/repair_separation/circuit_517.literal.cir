* Auto-generated SPICE netlist (NO TEXT OCR USED)

L1 n4 n2 1m
I1 n3 0 DC 1m
V1 0 n4 DC 15
R1 n3 0 1k
C1 n3 n1 1u
L2 n1 0 1m
R2 n2 n3 1k
R3 n3 0 1k

.op
.end
