* REPAIRED DECK -- interventions applied, listed below.
* The literal reconstruction is in the .literal.cir beside this file.
* interventions: 5
*   [gauge] unset_current_direction: kept drawn current-source reference direction
*   [gauge] ground_selection: used the GND symbol's net as reference (0)
*   [assumption/behaviour-changing] placeholder_values: assigned per-class placeholder values (no OCR)
*   [assumption/behaviour-changing] no_dc_path_to_ground: added shunt R 1e+09 from n9 to 0
*   [assumption] ideal_inductor_dc: none applied (DC short is well-posed); .nodeset available if singular
* Auto-generated SPICE netlist (NO TEXT OCR USED)

V1 n3 0 DC 15 AC 1
D1 n4 n1 Ddefault
D2 n5 n7 Zdefault
D3 n2 0 Zdefault
D4 n5 n6 Ddefault
D5 n1 n5 Zdefault
D6 n2 n5 Ddefault
D7 n7 0 Ddefault
I1 n9 0 DC 1m
L1 n7 n6 1m
L2 n3 n2 1m
C1 n9 n7 1u
R1 n4 n8 1k
C2 n2 n1 1u
C3 0 n5 1u
L3 n5 n4 1m
D8 n6 n4 Ddefault
.model Ddefault D
.model Zdefault D(bv=5.1)

.op
.end
