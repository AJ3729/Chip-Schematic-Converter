* REPAIRED DECK -- interventions applied, listed below.
* The literal reconstruction is in the .literal.cir beside this file.
* interventions: 5
*   [gauge] unset_current_direction: kept drawn current-source reference direction
*   [gauge] ground_selection: used the GND symbol's net as reference (0)
*   [assumption/behaviour-changing] placeholder_values: assigned per-class placeholder values (no OCR)
*   [assumption/behaviour-changing] no_dc_path_to_ground: added shunt R 1e+09 from n14 to 0
*   [assumption] ideal_inductor_dc: none applied (DC short is well-posed); .nodeset available if singular
* Auto-generated SPICE netlist (NO TEXT OCR USED)

E1 n2 0 0 n1 100k
E2 n6 0 n12 n10 100k
E3 n13 0 n11 n15 100k
E4 n8 0 n11 n9 100k
E5 n4 0 n3 n6 100k
I1 n14 n10 DC 1m
R1 n6 n9 1k
V1 n1 n7 DC 15
R2 n13 n5 1k
R3 n4 n5 1k
C1 n1 n2 1u
R4 n2 n3 1k
L1 n10 n6 1m
R5 n8 n5 1k
L2 n3 n4 1m
L3 n11 n13 1m
C2 n9 n8 1u
C3 n6 n11 1u

.op
.end
