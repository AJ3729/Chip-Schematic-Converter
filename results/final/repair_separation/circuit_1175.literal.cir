* Auto-generated SPICE netlist (NO TEXT OCR USED)

D1 n15 n17 Ddefault
Q1 n10 n13 n16 QNPNdefault
D2 n6 n5 Ddefault
Q2 n15 n12 n8 QPNPdefault
D3 n5 n3 Ddefault
R1 n11 n13 1k
Q3 n1 n3 n6 QNPNdefault
R2 n11 0 1k
Q4 n11 n9 n4 QPNPdefault
R3 n4 n7 1k
R4 n16 0 1k
R5 n12 n17 1k
R6 n14 n6 1k
R7 n5 n10 1k
R8 n2 n4 1k
R9 n15 0 1k
R10 n8 n9 1k
R11 n15 n19 1k
R12 n6 0 1k
R13 n1 n2 1k
V1 n2 0 DC 15
V2 n12 0 DC 15
R14 n18 0 1k
V3 n5 0 DC 15
V4 n1 0 DC 15
Q5 n15 n19 0 QNPNdefault
V5 n6 0 DC 15
Q6 n18 n14 0 QPNPdefault
D4 n7 n5 Ddefault
.model Ddefault D
.model QNPNdefault NPN
.model QPNPdefault PNP

.op
.end
