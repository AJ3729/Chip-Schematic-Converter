* Auto-generated SPICE netlist (NO TEXT OCR USED)

I1 n9 n7 DC 1m AC 1m
I2 n6 n7 DC 1m AC 1m
V1 n7 n3 DC 15 AC 1
M1 n4 n6 n8 n8 PMOSdefault
M2 n1 n2 n4 n4 PMOSdefault
M3 n8 n9 n7 n7 PMOSdefault
V2 n2 n7 DC 15 AC 1
M4 n1 n3 n4 n4 NMOSdefault
D1 n1 n2 Zdefault
V3 n1 0 DC 15
R1 n5 n8 1k
M5 n4 n2 n5 n5 NMOSdefault
M6 n5 n3 n7 n7 NMOSdefault
M7 n5 n3 n7 n7 NMOSdefault
.model NMOSdefault NMOS
.model PMOSdefault PMOS
.model Zdefault D(bv=5.1)

.op
.end
