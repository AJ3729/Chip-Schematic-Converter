* Auto-generated SPICE netlist (NO TEXT OCR USED)

I1 n1 0 DC 1m AC 1m
V1 n3 0 DC 15 AC 1
V2 n2 n1 DC 15 AC 1
C1 n3 0 1u
L1 n3 n2 1m
R1 n2 0 1k

.op
.end
