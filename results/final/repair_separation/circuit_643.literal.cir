* Auto-generated SPICE netlist (NO TEXT OCR USED)

I1 n4 n2 DC 1m AC 1m
V1 n3 n4 DC 15 AC 1
I2 n1 0 DC 1m
L1 n3 n6 1m
* SAME_NODE_SKIPPED V-DC both_on=0
L2 n3 n2 1m
V2 n2 0 DC 15
L3 n3 n4 1m
C1 n6 0 1u
C2 n5 0 1u
C3 n4 0 1u
L4 n3 n5 1m
C4 n2 0 1u

.op
.end
