* REPAIRED DECK -- interventions applied, listed below.
* The literal reconstruction is in the .literal.cir beside this file.
* interventions: 4
*   [gauge] ground_selection: used the GND symbol's net as reference (0)
*   [assumption/behaviour-changing] placeholder_values: assigned per-class placeholder values (no OCR)
*   [assumption/behaviour-changing] no_dc_path_to_ground: added shunt R 1e+09 from n1 to 0
*   [assumption] ideal_inductor_dc: none applied (DC short is well-posed); .nodeset available if singular
* Auto-generated SPICE netlist (NO TEXT OCR USED)

V1 n9 n12 DC 15 AC 1
E1 n6 0 n5 n7 100k
M1 n1 n1 n5 n5 NMOSdefault
D1 n1 n2 Zdefault
M2 n11 n15 n14 n14 NMOSdefault
M3 n3 n9 n10 n10 PMOSdefault
M4 n7 n8 n10 n10 PMOSdefault
M5 n4 n8 n11 n11 NMOSdefault
V2 n8 0 DC 15
M6 n10 n13 n14 n14 PMOSdefault
M7 n1 n2 n3 n3 NMOSdefault
M8 n1 n4 n1 n1 NMOSdefault
L1 n15 n13 1m
V3 n1 0 DC 15
L2 n6 n3 1m
.model NMOSdefault NMOS
.model PMOSdefault PMOS
.model Zdefault D(bv=5.1)

.op
.end
