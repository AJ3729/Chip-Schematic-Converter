* REPAIRED DECK -- interventions applied, listed below.
* The literal reconstruction is in the .literal.cir beside this file.
* interventions: 3
*   [gauge] unset_current_direction: kept drawn current-source reference direction
*   [gauge] ground_selection: used the GND symbol's net as reference (0)
*   [assumption/behaviour-changing] placeholder_values: assigned per-class placeholder values (no OCR)
* Auto-generated SPICE netlist (NO TEXT OCR USED)

I1 0 n1 DC 1m
C1 n2 n1 1u
V1 n3 0 DC 15
R1 n1 n3 1k
R2 n2 0 1k

.op
.end
