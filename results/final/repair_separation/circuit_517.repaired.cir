* REPAIRED DECK -- interventions applied, listed below.
* The literal reconstruction is in the .literal.cir beside this file.
* interventions: 4
*   [gauge] unset_current_direction: kept drawn current-source reference direction
*   [gauge] ground_selection: used the GND symbol's net as reference (0)
*   [assumption/behaviour-changing] placeholder_values: assigned per-class placeholder values (no OCR)
*   [assumption] ideal_inductor_dc: none applied (DC short is well-posed); .nodeset available if singular
* Auto-generated SPICE netlist (NO TEXT OCR USED)

L1 n4 n2 1m
I1 n3 0 DC 1m
V1 0 n4 DC 15
R1 n3 0 1k
C1 n3 n1 1u
L2 n1 0 1m
R2 n2 n3 1k
R3 n3 0 1k

.op
.end
