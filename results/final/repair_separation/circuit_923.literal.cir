* Auto-generated SPICE netlist (NO TEXT OCR USED)

V1 n2 0 DC 15 AC 1
L1 n2 n1 1m
R1 n1 0 1k
C1 n1 0 1u

.op
.end
