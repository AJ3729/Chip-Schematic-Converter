* Auto-generated SPICE netlist (NO TEXT OCR USED)

V1 n3 0 DC 15
I1 n1 n2 DC 1m
C1 n2 0 1u
R1 n3 n1 1k
L1 n3 n1 1m
R2 n2 0 1k
R3 n1 0 1k

.op
.end
