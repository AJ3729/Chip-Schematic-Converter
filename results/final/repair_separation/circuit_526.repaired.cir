* REPAIRED DECK -- interventions applied, listed below.
* The literal reconstruction is in the .literal.cir beside this file.
* interventions: 4
*   [gauge] unset_current_direction: kept drawn current-source reference direction
*   [gauge] ground_selection: used the GND symbol's net as reference (0)
*   [assumption/behaviour-changing] placeholder_values: assigned per-class placeholder values (no OCR)
*   [assumption] ideal_inductor_dc: none applied (DC short is well-posed); .nodeset available if singular
* Auto-generated SPICE netlist (NO TEXT OCR USED)

I1 n3 0 DC 1m
V1 n4 n5 DC 15
R1 n4 n3 1k
L1 n2 n5 1m
C1 0 n2 1u
R2 0 n1 1k
R3 n1 n4 1k
R4 0 n1 1k

.op
.end
