* Auto-generated SPICE netlist (NO TEXT OCR USED)

I1 n3 n4 DC 1m AC 1m
* SAME_NODE_SKIPPED I-DC both_on=0
V1 n1 n3 DC 15 AC 1
V2 0 n7 DC 15
V3 0 n4 DC 15
C1 n5 0 1u
C2 n6 n7 1u
C3 n4 0 1u
L1 n1 n4 1m
L2 n1 n5 1m
L3 n1 n2 1m
C4 n2 0 1u
L4 n1 n6 1m

.op
.end
