* Auto-generated SPICE netlist (NO TEXT OCR USED)

* SAME_NODE_SKIPPED I-AC both_on=0
* SAME_NODE_SKIPPED V-AC both_on=0
* SAME_NODE_SKIPPED V-DC both_on=0
* SAME_NODE_SKIPPED V-DC both_on=0
* SAME_NODE_SKIPPED I-DC both_on=0
* SAME_NODE_SKIPPED Capacitor both_on=0
* SAME_NODE_SKIPPED Capacitor both_on=0
* SAME_NODE_SKIPPED Capacitor both_on=0
* SAME_NODE_SKIPPED Inductor both_on=0
* SAME_NODE_SKIPPED Inductor both_on=0
* SAME_NODE_SKIPPED Capacitor both_on=0
* SAME_NODE_SKIPPED Inductor both_on=0
* SAME_NODE_SKIPPED Inductor both_on=0
* WARNING: no valid components written

.op
.end
