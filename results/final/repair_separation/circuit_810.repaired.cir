* REPAIRED DECK -- interventions applied, listed below.
* The literal reconstruction is in the .literal.cir beside this file.
* interventions: 6
*   [gauge] unset_current_direction: kept drawn current-source reference direction
*   [gauge] ground_selection: used the GND symbol's net as reference (0)
*   [assumption/behaviour-changing] placeholder_values: assigned per-class placeholder values (no OCR)
*   [assumption/behaviour-changing] no_dc_path_to_ground: added shunt R 1e+09 from n10 to 0
*   [assumption/behaviour-changing] no_dc_path_to_ground: added shunt R 1e+09 from n4 to 0
*   [assumption] ideal_inductor_dc: none applied (DC short is well-posed); .nodeset available if singular
* Auto-generated SPICE netlist (NO TEXT OCR USED)

V1 n1 0 DC 15 AC 1
I1 n10 0 DC 1m
D1 n4 0 Zdefault
D2 n5 n2 Ddefault
D3 n3 n5 Zdefault
D4 n8 0 Ddefault
L1 n1 n2 1m
D5 n7 n5 Ddefault
D6 n5 n8 Zdefault
C1 n10 n8 1u
D7 n7 n6 Ddefault
D8 n6 n3 Ddefault
L2 n8 n7 1m
L3 n5 n6 1m
C2 0 n5 1u
C3 n2 n3 1u
R1 n6 n9 1k
.model Ddefault D
.model Zdefault D(bv=5.1)

.op
.end
