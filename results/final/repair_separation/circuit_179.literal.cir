* Auto-generated SPICE netlist (NO TEXT OCR USED)

V1 n1 n4 DC 15 AC 1
I1 n3 n5 DC 1m AC 1m
C1 0 n4 1u
C2 n2 0 1u
R1 n3 n2 1k
L1 n2 n1 1m
L2 n5 0 1m
L3 n1 n4 1m

.op
.end
