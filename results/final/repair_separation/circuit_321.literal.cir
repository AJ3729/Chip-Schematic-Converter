* Auto-generated SPICE netlist (NO TEXT OCR USED)

I1 0 n1 DC 1m
I2 0 n1 DC 1m
R1 n3 n2 1k
V1 n3 0 DC 15
L1 n2 n1 1m
C1 n1 0 1u
R2 n2 0 1k

.op
.end
