* Auto-generated SPICE netlist (NO TEXT OCR USED)

R1 n2 n3 1k
L1 n3 n1 1m
V1 0 n2 DC 15
R2 n1 0 1k
C1 n1 0 1u

.op
.end
