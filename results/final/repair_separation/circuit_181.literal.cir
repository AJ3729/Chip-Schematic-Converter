* Auto-generated SPICE netlist (NO TEXT OCR USED)

I1 n9 0 DC 1m AC 1m
I2 n6 0 DC 1m AC 1m
D1 n1 n3 Zdefault
V1 n4 0 DC 15 AC 1
M1 n5 n6 n7 n7 PMOSdefault
M2 n1 n3 n5 n5 PMOSdefault
M3 n8 n4 0 0 NMOSdefault
V2 n3 0 DC 15 AC 1
V3 n1 n2 DC 15
M4 n5 n3 n8 n8 NMOSdefault
M5 n7 n9 0 0 PMOSdefault
M6 n1 n4 n5 n5 NMOSdefault
R1 n8 n7 1k
.model NMOSdefault NMOS
.model PMOSdefault PMOS
.model Zdefault D(bv=5.1)

.op
.end
