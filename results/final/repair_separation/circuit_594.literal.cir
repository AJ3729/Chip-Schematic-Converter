* Auto-generated SPICE netlist (NO TEXT OCR USED)

V1 n1 n2 DC 15 AC 1
I1 n2 n3 DC 1m AC 1m
V2 n3 0 DC 15
* SAME_NODE_SKIPPED V-DC both_on=0
* SAME_NODE_SKIPPED I-DC both_on=0
C1 n4 0 1u
L1 n1 n6 1m
L2 n1 n3 1m
L3 n1 n4 1m
L4 n1 n5 1m
C2 n6 0 1u
C3 n5 0 1u
C4 n3 0 1u

.op
.end
