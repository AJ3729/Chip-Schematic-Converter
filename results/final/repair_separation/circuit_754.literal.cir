* Auto-generated SPICE netlist (NO TEXT OCR USED)

V1 n11 n13 DC 15 AC 1
E1 n6 0 n7 n5 100k
D1 n1 n2 Zdefault
M1 n8 n7 n10 n10 PMOSdefault
M2 n4 n11 n10 n10 PMOSdefault
M3 n10 n15 0 0 PMOSdefault
M4 n1 n1 n3 n3 NMOSdefault
M5 n3 n8 n9 n9 NMOSdefault
V2 n12 n8 DC 15
M6 n1 n2 n4 n4 NMOSdefault
V3 n1 0 DC 15
L1 n6 n4 1m
M7 n9 n14 0 0 NMOSdefault
L2 n14 n15 1m
M8 n1 n1 n5 n5 NMOSdefault
M9 n1 n1 n5 n5 NMOSdefault
.model NMOSdefault NMOS
.model PMOSdefault PMOS
.model Zdefault D(bv=5.1)

.op
.end
