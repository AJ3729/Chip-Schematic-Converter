* REPAIRED DECK -- interventions applied, listed below.
* The literal reconstruction is in the .literal.cir beside this file.
* interventions: 5
*   [gauge] unset_current_direction: kept drawn current-source reference direction
*   [gauge] ground_selection: used the GND symbol's net as reference (0)
*   [assumption/behaviour-changing] placeholder_values: assigned per-class placeholder values (no OCR)
*   [assumption/behaviour-changing] no_dc_path_to_ground: added shunt R 1e+09 from n15 to 0
*   [assumption] ideal_inductor_dc: none applied (DC short is well-posed); .nodeset available if singular
* Auto-generated SPICE netlist (NO TEXT OCR USED)

E1 n4 0 n6 n3 100k
E2 n9 0 n11 n8 100k
E3 n6 0 n12 n10 100k
E4 n14 0 n16 n13 100k
E5 n2 0 0 n1 100k
R1 n2 n3 1k
I1 n10 n15 DC 1m
R2 n14 n5 1k
R3 n6 n8 1k
V1 n7 n1 DC 15
L1 n13 n14 1m
R4 n9 n5 1k
L2 n10 n6 1m
R5 n4 n5 1k
L3 n3 n4 1m
C1 n1 n2 1u
C2 n8 n9 1u
C3 n6 n13 1u
C4 n6 n13 1u

.op
.end
