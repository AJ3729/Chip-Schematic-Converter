* REPAIRED DECK -- interventions applied, listed below.
* The literal reconstruction is in the .literal.cir beside this file.
* interventions: 6
*   [gauge] unset_current_direction: kept drawn current-source reference direction
*   [assumption/behaviour-changing] placeholder_values: assigned per-class placeholder values (no OCR)
*   [assumption/behaviour-changing] no_dc_path_to_ground: added shunt R 1e+09 from n2 to 0
*   [assumption/behaviour-changing] no_dc_path_to_ground: added shunt R 1e+09 from n5 to 0
*   [assumption/behaviour-changing] no_dc_path_to_ground: added shunt R 1e+09 from n7 to 0
*   [assumption] ideal_inductor_dc: none applied (DC short is well-posed); .nodeset available if singular
* Auto-generated SPICE netlist (NO TEXT OCR USED)

I1 n3 n1 DC 1m AC 1m
V1 n1 n3 DC 15 AC 1
I2 0 n5 DC 1m
V2 0 n1 DC 15
V3 n7 0 DC 15
* SAME_NODE_SKIPPED Capacitor both_on=0
C1 n6 0 1u
C2 n4 0 1u
L1 n1 n4 1m
L2 n1 0 1m
L3 n2 n1 1m
C3 n1 0 1u
L4 n1 n6 1m

.op
.end
