* Auto-generated SPICE netlist (NO TEXT OCR USED)

R1 n2 0 1k
C1 n1 0 1u
V1 n2 n1 DC 15
I1 0 n2 DC 1m
L1 n1 0 1m

.op
.end
