* Auto-generated SPICE netlist (NO TEXT OCR USED)

I1 n3 0 DC 1m
V1 0 n1 DC 15
L1 n2 n3 1m
C1 n3 0 1u
R1 n1 n2 1k
R2 n3 0 1k

.op
.end
