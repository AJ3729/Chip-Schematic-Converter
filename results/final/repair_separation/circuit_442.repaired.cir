* REPAIRED DECK -- interventions applied, listed below.
* The literal reconstruction is in the .literal.cir beside this file.
* interventions: 4
*   [gauge] unset_current_direction: kept drawn current-source reference direction
*   [gauge] ground_selection: used the GND symbol's net as reference (0)
*   [assumption/behaviour-changing] placeholder_values: assigned per-class placeholder values (no OCR)
*   [assumption] ideal_inductor_dc: none applied (DC short is well-posed); .nodeset available if singular
* Auto-generated SPICE netlist (NO TEXT OCR USED)

I1 n2 0 DC 1m
L1 n3 n1 1m
L2 n5 n2 1m
C1 n3 n5 1u
V1 n4 0 DC 15
R1 n1 n2 1k
R2 n4 n3 1k
R3 n2 0 1k

.op
.end
