* Auto-generated SPICE netlist (NO TEXT OCR USED)

I1 n1 n4 DC 1m AC 1m
V1 n2 0 DC 15 AC 1
R1 n1 n2 1k
L1 n4 n3 1m
C1 n3 0 1u
C2 n1 n3 1u
R2 n4 0 1k

.op
.end
