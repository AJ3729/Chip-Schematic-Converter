* Auto-generated SPICE netlist (NO TEXT OCR USED)

V1 n4 n3 DC 15 AC 1
V2 n2 0 DC 15 AC 1
C1 n1 n3 1u
L1 0 n1 1m
R1 0 n4 1k
R2 n2 0 1k

.op
.end
