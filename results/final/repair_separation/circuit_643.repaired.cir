* REPAIRED DECK -- interventions applied, listed below.
* The literal reconstruction is in the .literal.cir beside this file.
* interventions: 5
*   [gauge] unset_current_direction: kept drawn current-source reference direction
*   [gauge] ground_selection: used the GND symbol's net as reference (0)
*   [assumption/behaviour-changing] placeholder_values: assigned per-class placeholder values (no OCR)
*   [assumption/behaviour-changing] no_dc_path_to_ground: added shunt R 1e+09 from n1 to 0
*   [assumption] ideal_inductor_dc: none applied (DC short is well-posed); .nodeset available if singular
* Auto-generated SPICE netlist (NO TEXT OCR USED)

I1 n4 n2 DC 1m AC 1m
V1 n3 n4 DC 15 AC 1
I2 n1 0 DC 1m
L1 n3 n6 1m
* SAME_NODE_SKIPPED V-DC both_on=0
L2 n3 n2 1m
V2 n2 0 DC 15
L3 n3 n4 1m
C1 n6 0 1u
C2 n5 0 1u
C3 n4 0 1u
L4 n3 n5 1m
C4 n2 0 1u

.op
.end
