* Auto-generated SPICE netlist (NO TEXT OCR USED)

I1 0 n1 DC 1m
C1 n2 n1 1u
V1 n3 0 DC 15
R1 n1 n3 1k
R2 n2 0 1k

.op
.end
