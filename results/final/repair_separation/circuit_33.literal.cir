* Auto-generated SPICE netlist (NO TEXT OCR USED)

Q1 n11 n8 n6 QPNPdefault
Q2 n13 n12 n7 QPNPdefault
D1 n9 n5 Ddefault
Q3 n14 n9 n4 QPNPdefault
D2 n5 n3 Ddefault
Q4 n4 n14 0 QNPNdefault
Q5 n8 n10 0 QNPNdefault
Q6 n9 n13 0 QNPNdefault
R1 n6 n7 1k
V1 n2 0 DC 15
V2 n4 0 DC 15
V3 n7 0 DC 15
R2 n7 n4 1k
Q7 n13 n15 0 QNPNdefault
Q8 n1 n3 n4 QNPNdefault
R3 n2 n6 1k
R4 n12 0 1k
V4 n1 0 DC 15
V5 n10 0 DC 15
R5 n10 0 1k
R6 n1 n2 1k
Q9 n11 n15 0 QNPNdefault
.model Ddefault D
.model QNPNdefault NPN
.model QPNPdefault PNP

.op
.end
