* Auto-generated SPICE netlist (NO TEXT OCR USED)

C1 0 n1 1u
V1 n3 0 DC 15
C2 n2 n1 1u
I1 n1 n4 DC 1m
L1 n4 n3 1m
R1 n2 0 1k

.op
.end
