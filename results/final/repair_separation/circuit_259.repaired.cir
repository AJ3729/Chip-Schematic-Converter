* REPAIRED DECK -- interventions applied, listed below.
* The literal reconstruction is in the .literal.cir beside this file.
* interventions: 5
*   [gauge] unset_current_direction: kept drawn current-source reference direction
*   [gauge] ground_selection: used the GND symbol's net as reference (0)
*   [assumption/behaviour-changing] placeholder_values: assigned per-class placeholder values (no OCR)
*   [assumption/behaviour-changing] no_dc_path_to_ground: added shunt R 1e+09 from n6 to 0
*   [assumption/behaviour-changing] no_dc_path_to_ground: added shunt R 1e+09 from n9 to 0
* Auto-generated SPICE netlist (NO TEXT OCR USED)

I1 n6 0 DC 1m AC 1m
M1 n5 n6 n7 n7 PMOSdefault
I2 n9 0 DC 1m AC 1m
M2 n1 n4 n5 n5 PMOSdefault
M3 n8 0 n3 n3 NMOSdefault
D1 n1 n4 Zdefault
V1 n3 0 DC 15 AC 1
M4 n1 n3 n5 n5 NMOSdefault
M5 n7 n9 0 0 PMOSdefault
M6 n4 n8 n5 n5 NMOSdefault
V2 n4 0 DC 15 AC 1
V3 n2 n1 DC 15
R1 n8 n7 1k
.model NMOSdefault NMOS
.model PMOSdefault PMOS
.model Zdefault D(bv=5.1)

.op
.end
