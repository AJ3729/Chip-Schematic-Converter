* REPAIRED DECK -- interventions applied, listed below.
* The literal reconstruction is in the .literal.cir beside this file.
* interventions: 5
*   [gauge] unset_current_direction: kept drawn current-source reference direction
*   [gauge] ground_selection: used the GND symbol's net as reference (0)
*   [assumption/behaviour-changing] placeholder_values: assigned per-class placeholder values (no OCR)
*   [assumption/behaviour-changing] no_dc_path_to_ground: added shunt R 1e+09 from n13 to 0
*   [assumption] ideal_inductor_dc: none applied (DC short is well-posed); .nodeset available if singular
* Auto-generated SPICE netlist (NO TEXT OCR USED)

E1 n2 0 0 n1 100k
E2 n15 0 n16 n14 100k
E3 n9 0 n11 n8 100k
E4 n6 0 n12 n10 100k
E5 n4 0 n6 n3 100k
I1 n10 n13 DC 1m
R1 n15 n5 1k
R2 n4 n5 1k
V1 n1 n7 DC 15
R3 n2 n3 1k
R4 n9 n5 1k
C1 n8 n9 1u
L1 n10 n6 1m
L2 n3 n4 1m
C2 n6 n14 1u
C3 n1 n2 1u
L3 n14 n15 1m
R5 n6 n8 1k

.op
.end
