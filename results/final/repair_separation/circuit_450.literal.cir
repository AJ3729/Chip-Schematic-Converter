* Auto-generated SPICE netlist (NO TEXT OCR USED)

I1 n1 0 DC 1m
R1 n1 n3 1k
C1 n2 0 1u
R2 n1 n2 1k
L1 n3 n4 1m

.op
.end
