* Auto-generated SPICE netlist (NO TEXT OCR USED)

C1 n2 n1 1u
I1 n2 0 DC 1m
R1 n1 0 1k
L1 n2 n1 1m
R2 n2 0 1k

.op
.end
