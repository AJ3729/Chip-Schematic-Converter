* REPAIRED DECK -- interventions applied, listed below.
* The literal reconstruction is in the .literal.cir beside this file.
* interventions: 5
*   [gauge] unset_current_direction: kept drawn current-source reference direction
*   [gauge] ground_selection: used the GND symbol's net as reference (0)
*   [assumption/behaviour-changing] placeholder_values: assigned per-class placeholder values (no OCR)
*   [assumption/behaviour-changing] no_dc_path_to_ground: added shunt R 1e+09 from n7 to 0
*   [assumption] ideal_inductor_dc: none applied (DC short is well-posed); .nodeset available if singular
* Auto-generated SPICE netlist (NO TEXT OCR USED)

D1 n3 n4 Zdefault
D2 n4 n1 Ddefault
D3 n6 n5 Ddefault
D4 n1 0 Zdefault
D5 n4 n8 Zdefault
D6 n6 n4 Ddefault
D7 n5 n3 Ddefault
V1 0 n2 DC 15
L1 n4 n5 1m
D8 n8 0 Ddefault
I1 0 n7 DC 1m
L2 n8 n6 1m
C1 0 n4 1u
L3 n2 n1 1m
C2 n7 n8 1u
C3 n1 n3 1u
R1 n5 0 1k
.model Ddefault D
.model Zdefault D(bv=5.1)

.op
.end
