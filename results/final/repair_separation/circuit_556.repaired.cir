* REPAIRED DECK -- interventions applied, listed below.
* The literal reconstruction is in the .literal.cir beside this file.
* interventions: 6
*   [gauge] unset_current_direction: kept drawn current-source reference direction
*   [gauge] ground_selection: used the GND symbol's net as reference (0)
*   [assumption/behaviour-changing] placeholder_values: assigned per-class placeholder values (no OCR)
*   [assumption/behaviour-changing] no_dc_path_to_ground: added shunt R 1e+09 from n10 to 0
*   [assumption/behaviour-changing] no_dc_path_to_ground: added shunt R 1e+09 from n5 to 0
*   [assumption/behaviour-changing] no_dc_path_to_ground: added shunt R 1e+09 from n8 to 0
* Auto-generated SPICE netlist (NO TEXT OCR USED)

M1 n1 n4 n3 n3 PMOSdefault
V1 n2 n7 DC 15 AC 1
I1 n9 n10 DC 1m AC 1m
V2 n4 n7 DC 15 AC 1
M2 n6 n8 n7 n7 PMOSdefault
M3 n5 n3 n6 n6 PMOSdefault
I2 n8 n7 DC 1m AC 1m
M4 n1 n2 n3 n3 NMOSdefault
M5 n2 n4 n7 n7 NMOSdefault
D1 n1 n4 Zdefault
V3 n1 0 DC 15
R1 n4 n6 1k
.model NMOSdefault NMOS
.model PMOSdefault PMOS
.model Zdefault D(bv=5.1)

.op
.end
