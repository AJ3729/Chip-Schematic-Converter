* Auto-generated SPICE netlist (NO TEXT OCR USED)

I1 0 n1 DC 1m
C1 0 n2 1u
I2 0 n1 DC 1m
V1 n2 n4 DC 15
R1 n3 n4 1k
L1 n3 n1 1m
R2 n1 0 1k

.op
.end
