* Auto-generated SPICE netlist (NO TEXT OCR USED)

V1 n9 n12 DC 15 AC 1
E1 n6 0 n5 n7 100k
M1 n1 n1 n5 n5 NMOSdefault
D1 n1 n2 Zdefault
M2 n11 n15 n14 n14 NMOSdefault
M3 n3 n9 n10 n10 PMOSdefault
M4 n7 n8 n10 n10 PMOSdefault
M5 n4 n8 n11 n11 NMOSdefault
V2 n8 0 DC 15
M6 n10 n13 n14 n14 PMOSdefault
M7 n1 n2 n3 n3 NMOSdefault
M8 n1 n4 n1 n1 NMOSdefault
L1 n15 n13 1m
V3 n1 0 DC 15
L2 n6 n3 1m
.model NMOSdefault NMOS
.model PMOSdefault PMOS
.model Zdefault D(bv=5.1)

.op
.end
