* REPAIRED DECK -- interventions applied, listed below.
* The literal reconstruction is in the .literal.cir beside this file.
* interventions: 3
*   [gauge] ground_selection: used the GND symbol's net as reference (0)
*   [assumption/behaviour-changing] placeholder_values: assigned per-class placeholder values (no OCR)
*   [assumption] ideal_inductor_dc: none applied (DC short is well-posed); .nodeset available if singular
* Auto-generated SPICE netlist (NO TEXT OCR USED)

V1 0 n3 DC 15
C1 n1 n2 1u
L1 n2 n4 1m
C2 n2 0 1u
R1 n1 0 1k
R2 n4 n3 1k

.op
.end
