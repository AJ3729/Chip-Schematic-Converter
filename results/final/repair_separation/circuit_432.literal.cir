* Auto-generated SPICE netlist (NO TEXT OCR USED)

V1 n1 n5 DC 15 AC 1
I1 n9 n5 DC 1m
D1 n3 n4 Zdefault
D2 n4 n8 Zdefault
D3 n6 n3 Ddefault
D4 n2 n5 Zdefault
D5 n4 n7 Ddefault
L1 n1 n2 1m
D6 n4 n2 Ddefault
D7 n8 n5 Ddefault
D8 n7 n6 Ddefault
C1 n2 n3 1u
L2 n4 n6 1m
C2 n9 n8 1u
L3 n8 n7 1m
R1 n6 0 1k
C3 n5 n4 1u
.model Ddefault D
.model Zdefault D(bv=5.1)

.op
.end
