* Auto-generated SPICE netlist (NO TEXT OCR USED)

I1 n3 0 DC 1m
C1 n3 n2 1u
L1 n2 0 1m
V1 0 n4 DC 15
R1 n1 n3 1k
R2 n1 0 1k
R3 n2 n4 1k

.op
.end
