* REPAIRED DECK -- interventions applied, listed below.
* The literal reconstruction is in the .literal.cir beside this file.
* interventions: 6
*   [gauge] unset_current_direction: kept drawn current-source reference direction
*   [gauge] ground_selection: used the GND symbol's net as reference (0)
*   [assumption/behaviour-changing] placeholder_values: assigned per-class placeholder values (no OCR)
*   [assumption/behaviour-changing] no_dc_path_to_ground: added shunt R 1e+09 from n1 to 0
*   [assumption] ideal_inductor_dc: none applied (DC short is well-posed); .nodeset available if singular
*   [assumption] unsnapped_terminal: flagged only — not auto-repaired (would change topology)
* Auto-generated SPICE netlist (NO TEXT OCR USED)

I1 n2 0 DC 1m AC 1m
V1 n4 0 DC 15 AC 1
* UNSNAPPED Resistor raw_nodes=[0, 1]
* UNSNAPPED Resistor raw_nodes=[0, 1]
C1 n3 0 1u
* UNSNAPPED Inductor raw_nodes=[0, 1]
L1 n1 n3 1m
R1 n2 0 1k

.op
.end
