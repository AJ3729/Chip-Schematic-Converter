* Auto-generated SPICE netlist (NO TEXT OCR USED)

I1 n7 0 DC 1m
V1 n2 n4 DC 15
R1 n1 n2 1k
R2 n3 n1 1k
R3 n5 n7 1k
R4 n4 n6 1k
R5 n1 n4 1k
L1 0 n6 1m
V2 n3 n5 DC 15
R6 n4 0 1k
C1 n5 n4 1u

.op
.end
