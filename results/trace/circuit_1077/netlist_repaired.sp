* Auto-generated SPICE netlist (NO TEXT OCR USED)

V1 n3 0 AC 1
R1 n1 n4 1k
R2 n3 n1 1k
L1 n4 0 1m
R3 n1 n2 1k
C1 n2 0 1u

.op
.end
