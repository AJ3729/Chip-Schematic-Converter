* Auto-generated SPICE netlist (NO TEXT OCR USED)

V1 n4 0 DC 5
I1 n3 0 DC 1m
* UNSNAPPED DC Supply raw_nodes=[None, None]
* UNSNAPPED capacitor raw_nodes=[None, None]
L1 n1 n2 1m
R1 n3 0 1k
L2 n3 n4 1m
R2 n2 n3 1k

.op
.end
